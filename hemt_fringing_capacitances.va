```verilog id="hemt_fringe_cap"
//==============================================================================
//  HEMT Fringing Capacitance Model (Analytical / Guildenblatt-Based)
//  Part of GaN HEMT Compact Model Library
//
//  Version      : v1.0.0
//  Release Date : 2026-06-19
//
//  Description:
//      Analytical fringing capacitance model for GaN HEMT devices based on
//      bias-dependent electrostatic formulation. Captures gate-source and
//      gate-drain fringing charge contributions using modified Guildenblatt
//      approach.
//
//  Developed by:

//  * Sahra Ebrahimmagham (Researcher, AUT)
//  * Dr. Majid Shalchian (Assistant Professor, AUT)
//  * Dr. Farzan Jazaeri (Researcher, EPFL)
//
//  Affiliations:
//
//  * Amirkabir University of Technology (AUT)
//  * École Polytechnique Fédérale de Lausanne (EPFL)
//
//
//  ## License
//
//This project is released under the **MIT License**.
//
//See `LICENSE` file for details.
//==============================================================================

//==============================================================================
// HEMT FRINGING CAPACITANCE CALCULATION (SOURCE / DRAIN SIDE)
//==============================================================================

begin : HEMT_FRINGING_CAPACITANCES

    //--------------------------------------------------------------------------
    // Source-side fringing charge (HEMT)
    //--------------------------------------------------------------------------

    tmp = vbi + VFR / UT + vs - (psi_p - 2.0 * qs);

    hemt_QSFR = Weffc * NF * KJF *
                (1.0 + CJF * UT * vs) *
                sqrt(UT * `MAXA(tmp, 0.0, DFR));

    //--------------------------------------------------------------------------
    // Drain-side fringing charge (HEMT)
    //--------------------------------------------------------------------------

    tmp = vbi + VFR / UT + vdp - (psi_p - 2.0 * qdp);

    hemt_QDFR = Weffc * NF * KJF *
                (1.0 + CJF * UT * vdp) *
                sqrt(UT * `MAXA(tmp, 0.0, DFR));

end // HEMT_FRINGING_CAPACITANCES

//==============================================================================
// DYNAMIC CAPACITIVE CURRENTS (HEMT FRINGING EFFECT)
//==============================================================================

I(d, g) <+ SIGN_M * ddt(hemt_QDFR);
I(s, g) <+ SIGN_M * ddt(hemt_QSFR);
```
