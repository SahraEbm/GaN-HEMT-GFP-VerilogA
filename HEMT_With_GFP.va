// *****************************************************************************
// *  HEMT with Gate Field Plate MODEL released by Sahra Ebrahimmagham on 06/19/2026        *
// *  Verilog-A Model                                                         *
// ****************************************************************************
//
// ****************************************************************************
// *  Copyright 2026 Amirkabir UNiversirt of Technology (AUT) & EPFL              *
// *  All rights reserved.                                                                               *
// *                                                                                                           *
// *  Project director: Sahra Ebrahimmagham                                                   *
// *                                                                                                           *
// *  Current developers:  Sahra Ebrahimmagham (Researcher, AUT)                     *
// *                              Dr. Majid Shalchian (Assistant Professor, AUT)              *
// *                              Dr. Farzan Jazzeri( Researcher, EPFL)                        *
// *                                                                                                            *
// *                                                                                                            *
// *                                                                                                            *
// ****************************************************************************
//
// ****************************************************************************
// *  Software is distributed as is, completely without warranty or service             *
// *  support. The Amirkabir University of Technology and EPFL and  their             *
// *  its employees  are not liable for the condition or performance                         *
// *  of the software.                                                                                    *
// *  The Amirkabir University of Technology and EPFL owns the copyright             *
// *  and grants users a perpetual, irrevocable, worldwide, non-exclusive,                 *
// *  royalty-free license with respect to the software as set forth below.              *
// *                                                                          *
// *  AUT and EPFL hereby disclaims all implied warranties.                   *
// *                                                                          *
// *  Amirkabir University of Technology and EPFL grants the users the right  *
// *  to modify, copy, and redistribute the software and documentation,       *
// *  both within the user's organization and externally, subject to the      *
// *  following  restrictions:                                                *
// *                                                                          *
// *  1. The users agree not to charge for AUT and EPFL code                  *
// *     itself but may charge for additions, extensions, or support.         *
// *                                                                          *
// *  2. In any product based on the software, the users agree to             *
// *     acknowledge the AUT and EPFL that developed the                      *
// *     software. This acknowledgment shall appear in the product            *
// *     documentation.                                                       *
// *                                                                          *
// *  3. Redistributions to others of source code and documentation must      *
// *     retain the copyright notice, disclaimer, and list of conditions.     *
// *                                                                          *
// *  4. Redistributions to others in binary form must reproduce the          *
// *     copyright notice, disclaimer, and list of conditions in the          *
// *     documentation and/or other materials provided with the               *
// *     distribution.                                                        *
// *                                                                          *
// *  Agreed to on _________Jun. 19, 2026__________                           *
// *                                                                          *
// *  By: ____Amirkabir University of Technology and EPFL___                  *
// *      ____Sahra Ebrahimmagham, Majid Shalchian , Farzan Jazzeri_____________________           *
// *      ____Researcher, Assistant Professor, Researcher________                         *
// ****************************************************************************

`include "constants.vams"
`include "disciplines.vams"
//
//***********************************************
//
// Disable strobe for improved performance speed
//
//***********************************************
//
// `define DISABLE_STROBE
`ifdef DISABLE_STROBE
    `define STROBE(X)
    `define STROBE2(X,Y)
`else
    `define STROBE(X) $strobe(X)
    `define STROBE2(X,Y) $strobe(X,Y)
`endif
//
//***********************************************
//
// Define Functions
//
//***********************************************
//
//
//***********************************************
//
// Normalized pinch-off voltage
//
//***********************************************
//
`define pinch_norm(vg_vA, gamma, pinch_n) \
    T1       = 0.5*vg_vA - 3.0 * (1.0 + gamma / `M_SQRT2); \
    T2       = (T1 + sqrt(T1 * T1 + 6.0 * vg_vA)); \
    if (vg_vA < 0.0) begin \
        T3   = (vg_vA - T2) / gamma; \
        pinch_n = -lln(1.0 - T2 + T3 * T3); \
    end else begin \
        T3   = lexp(-T2); \
        T1   = 0.5 * gamma; \
        T2   = sqrt(vg_vA - 1.0 + T3 + T1 * T1) - T1; \
        pinch_n = T2 * T2 + 1.0 - T3; \
    end \
//
//***********************************************
//
// Define core Function
//
//***********************************************
//
`define Core(vch,pinch_n,n_q,gam,cb,DOS_2D,gg,UTT,v_s,phib,core)       \
     vrbl=pinch_n-v_s+phib-vch;  \
     Qsp=2*n_q*cb*UTT;        \
     a=q/(cb*n_q);     \
     n0=DOS_2D*UTT;       \
     alpha=a*n0/UTT;       \
     if (vrbl <= 0.0) begin       \
	     T0 = 6 / exp(vrbl);     \
         T1 =(T0+alpha+2/3*beta*(T0)**(1/3))/(1+vrbl+ln(T0)-1/3*beta*(T0)**(-2/3));     \
         T2 =(T1+alpha+2/3*beta*(T1)**(1/3))/(1+vrbl+ln(T1)-1/3*beta*(T1)**(-2/3));     \
         T4 =(1+vrbl+ln(T2)-1/3*beta*(T2)**(-2/3))/(T2+alpha+2/3*beta*(T2)**(1/3));     \
		 core =q*n0*T4/Qsp;       \
     end else begin        \
	 if (vrbl<50) begin         \
            T0=1/((vrbl/(alpha+beta))+0.5);      \
            T1=(T0+alpha+2/3*beta*(T0)**(1/3))/(1+vrbl+ln(T0)-1/3*beta*(T0)**(-2/3));       \
            T2=(T1+alpha+2/3*beta*(T1)**(1/3))/(1+vrbl+ln(T1)-1/3*beta*(T1)**(-2/3));        \
            T4=(1.0+vrbl+ln(T2)-1/3*beta*(T2)**(-2/3))/(T2+alpha+2/3*beta*(T2)**(1/3));      \
     end else begin       \
            T0=3/((vrbl/(alpha+beta))+0.5);       \
            T1=(1+alpha+2/3*beta*(T0)**(1/3))/(0.5+vrbl-1/3*beta*(T0)**(-2/3));       \
            T2=(1+alpha+2/3*beta*(T1)**(1/3))/(0.5+vrbl-1/3*beta*(T1)**(-2/3));      \
            T3=(1+alpha+2/3*beta*(T2)**(1/3))/(0.5+vrbl-1/3*beta*(T2)**(-2/3));       \
           T4=(1.0+1*vrbl-1/3*beta*(T3)**(-2/3))/(1.0+alpha+2/3*beta*(T3)**(1/3));       \
		   core =q*n0*T4/Qsp;    \
     end     \
	 end     \

//
//***********************************************
//
// Smoothing function for (max of x, x0 with deltax)
//
//***********************************************
//
`define Smooth(x, x0, deltax, xsmooth) \
    xsmooth = 0.5 * (x + x0 + sqrt((x - x0) * (x - x0) + 0.25 * deltax * deltax)); \

// Smoothing function for (max of x, x0 with deltax)
`define Smooth1(x, x0, deltax, xsmooth) \
    xsmooth = 0.5 * (x + x0 + sqrt((x - x0) * (x - x0) + 0.25 * deltax * deltax)) - 0.25 * deltax; \

// Smoothing function for (min of x, x0 with deltax)
`define Smooth2(x, x0, deltax, xsmooth) \
    xsmooth = 0.5 * (x + x0 - sqrt((x - x0) * (x - x0) + 0.25 * deltax * deltax)) + 0.25 * deltax; \

// Smoothing function for (min of x, x0 with deltax)
`define Min1(x, x0, deltax, xsmooth) \
    xsmooth = 0.5 * (x + x0 - sqrt((x - x0) * (x - x0) + 0.25 * deltax * deltax)); \
//
//***********************************************
//
// Numerical Constants
//
//***********************************************
//
`define EXPL_THRESHOLD  80.0
`define MAX_EXPL        5.540622384e34
`define MIN_EXPL        1.804851387e-35
`define N_MINLOG        1.0e-38
`define DELTA_1         0.02
`define Oneby3          0.33333333333333333

//
//***********************************************
//
// Physical Constants
//
//***********************************************
//
`define type_n       1
`define type_p       -1
`define q           1.60219e-19
`define EP0        8.85418e-12
`define Kb_q        8.617087e-5      // Joule/degree
`define  me         9.11e-31
//
//***********************************************
//
//
//
//***********************************************
//
module EPFL_HEMTGFP(d, g, s, b, t);
inout d, g, s, b, t;
electrical d, g, s, b;
electrical gi,si,di,fp1;
thermal t;
//
//***********************************************
//
//parameters
//
//***********************************************
//
parameter real		    L 		= 10.0E-06	   from [1.0E-9:inf) 	`ATTR(type="instance" info="GATE'S LENGTH");

parameter real	    	W 		= 1.0E-06	   from [1.0E-9:inf) 	`ATTR(type="instance" info="GATE'S WIDTH");

parameter integer       NF 	= 1		       from [1:inf) 		    `ATTR(type="instance" info="NUMBER OF FINGERS");

parameter real		    M 		= 1		       from [1:inf) 		    `ATTR(type="instance" info="NUMBER OF DEVICES IN PARALLEL");

parameter real		   AD 	= 0.0 		   from [0.0:inf) 		`ATTR(type="instance" info="DRAIN'S AREA");

parameter real		   AS 		= 0.0		       from [0.0:inf) 		`ATTR(type="instance" info="SOURCE'S AREA");

parameter real		  PD 		= 0.0		       from [0.0:inf) 		`ATTR(type="instance" info="DRAIN'S PERIMETER");

parameter real	   	PS 		= 0.0		      from [0.0:inf) 		`ATTR(type="instance" info="SOURCE'S PERIMETER");

parameter real 		SA 		= 0.0		      from [0.0:inf)		`ATTR(type="instance" info="STI PARAMETER; DISTANCE FROM STI (SIDE A)");

parameter real 		SB 		= 0.0		      from [0.0:inf)		`ATTR(type="instance" info="STI PARAMETER; DISTANCE FROM STI (SIDE B)");

parameter real 		SD 		= 0.0 	     from [0.0:inf)		    `ATTR(type="instance" info="STI PARAMETER; DISTANCE BETWEEN GATES");

//
//***********************************************
//
// FLAGS AND SETUP PARAMETERS //
//
//***********************************************
//
parameter real		TNOM 		= 27.0		from [-273.15:inf)    	`ATTR(info="NOMINAL TEMPERATURE FOR MODEL PARAMETERS");

parameter real		SCALE 		= 1.0		    from (0.0:inf)		        `ATTR(info="SCALING SIZE FACTOR");

parameter real		XL 		    = 0.0 		from (-inf:inf)		        `ATTR(info="OPTICAL OFFSET FOR CHANNEL LENGTH");

parameter real		XW 		    = 0.0 		from (-inf:inf)		        `ATTR(info="OPTICAL OFFSET FOR CHANNEL WIDTH");

//parameter real 	NQS_NOI 	 = 1.0		    from [0:1]		            `ATTR(info="FLAG TURNING ON NQS THERMAL NOISE MODEL. (NOT BOTH NQS_NOI AND TH_NOI SHOULD BE SET TO 1).");

//parameter real 	TH_NOI  	 = 0.0	   	 from [0:1]		            `ATTR(info="FLAG TURNING ON SHORT CHANNEL EFFECTS THERMAL NOISE MODEL. (NOT BOTH NQS_NOI AND TH_NOI SHOULD BE SET TO 1).");

parameter real 		INFO_LEVEL = 0.0		   from [0:inf)		        `ATTR(info="FLAG FOR INFORMATION PRINTOUT. CURRENTLY ONLY VALUE OF 1 IS SUPPORTED.");

parameter real		QOFF 		   = 0.0		    from [0:1]		         `ATTR(info="FLAG FOR TURNING OFF THE DYNAMIC BEHAVIOUR OF THE MODEL (FOR DEBUGGING PURPOSES)");

// MATCHING

parameter real		AVTO 		   = 0.0 		    from (-inf:inf)		     `ATTR(info="MATCHING PARAMETER FOR THQOFFHOLD VOLTAGE (VTO)");

parameter real		AGAMMA 		= 0.0 		from (-inf:inf)		     `ATTR(info="MATCHING PARAMETER FOR BODY FACTOR (GAMMA)");

parameter real		AKP		        = 0.0 		from (-inf:inf)		     `ATTR(info="MATCHING PARAMETER FOR MOBILITY (KP)");

parameter real		ADPHIEDGE	 = 0.0 		from (-inf:inf)		     `ATTR(info="MATCHING PARAMETER FOR THRESHOLD VOLTAGE OF EDGE DEVICE(DPHIEDGE)");

parameter real		EDGEP1	    	= 0.0 		from (-inf:inf)		     `ATTR(info="EDGEP1");

parameter real		EDGEP2		= 0.0 		from (-inf:inf)		     `ATTR(info="EDGEP2");

parameter real		STDC		        = 0.0 		from (-inf:inf)		     `ATTR(info="STDC");

parameter real       AGAMMAEDGE = 0.0        from (-inf:inf)	       	`ATTR(info="AGAMMAEDGE");

//
//***********************************************
//
// MODEL PARAMETERS //
//
//***********************************************
//
// AlGaN, SUBSTRATE AND GATE DOPING RELATED PARAMETERS (7(8))

parameter real		Cb 		= 0.0025		  from (0.0:inf)		`ATTR(info="AlGaN CAPACITANCE PER UNIT AREA");

parameter real		XJ 		= 20.0E-09 	  from (0.0:inf)		`ATTR(info="DEPTH OF JUNCTION (SOURCE AND DRAIN)");

parameter real      NA      = (1e16)*(1e6)      from (0.0:inf)		`ATTR(info="Doping of GaN layer");

parameter real      ND      = (6e16)*(1e6)     from (0.0:inf)		`ATTR(info="Doping of AlGaN layer");

parameter real      xx           =  0.3              from (0.0:1)		    `ATTR(info="percentage of Al in AlxxGa(1-xx)N");

parameter real      sigma_pol  =  0               from (-inf:inf)		`ATTR(info="polarization charge density in AlGaN/Gan interface");

parameter real      Phi_B   =   0                  from (-inf:inf)		`ATTR(info="gate Schottky barrier ");

parameter real      x1      =  -30e-9             from (-inf:0)		    `ATTR(info="AlGaN Layer Thickness (with negative sign) ");

parameter real		VTO 	= 0.3		             from (-inf:inf)		    `ATTR(info="THRESHOLD VOLTAGE");

parameter real      gu      = 0.2e-12            from (0:inf)		    `ATTR(info="EXPERIMENTALLY DETERMINED PARAMETER");

parameter real		PHIF 		= 0.45		 from [0.0:inf)		    `ATTR(info="FERMI BULK POTENTIAL");

parameter real		GAMMAG 		= 4.1		 from (0.0:inf)		    `ATTR(info="GATE DOPING COEFFICIENT FOR POLYSILICON DEPLETION EFFECT");

parameter real		N0 		= 1.0		         from [0.0:inf) 		`ATTR(info="WEAK INVERSION FINE TUNING PARAMETER");

parameter real 		VBI 		= 0.0		         from [0.0:inf) 		`ATTR(info="BUILT-IN VOLTAGE DROP-OFF. IF LEFT TO DEFAULT ZERO VALUE, IT IS SET TO THE NOMINAL VALUE OF 3UT HIGHER THAN PHI.");
//
//***********************************************
//// FIELD-PLATE PARAMETERS
//
//***********************************************
//
parameter integer   FLAGFP1 = 1            from [0:1]                   `ATTR(info="FIELD-PLATE ENABLE FLAG");

parameter real       LGFP1 = 2.0E-6        from [0.0:inf)              `ATTR(info="FIELD-PLATE LENGTH");

parameter real       VTOFP1 = -3.3          from (-inf:inf)             `ATTR(info="FIELD-PLATE THRESHOLD VOLTAGE");

parameter real       CBFP1 = 0.0              from [0.0:inf)             `ATTR(info="FIELD-PLATE  CAPACITANCE PER UNIT WIDTH");
//

//***********************************************
//
// QUANTUM EFFECTS (3)
//
//***********************************************
//
parameter real		AQMA 		= 0.5		from [0.0:inf) 		`ATTR(info="QUANTUM MECHANICAL EFFECT ACCUMULATION REGION COEFFICIENT");

parameter real		AQMI 		= 0.4		from [0.0:inf) 		`ATTR(info="QUANTUM MECHANICAL EFFECT INVERSION REGION COEFFICIENT");

parameter real		ETAQM 		= 0.75		from [0.0:inf) 		`ATTR(info="QUANTUM MECHANICAL EFFECT ACCUMULATION ETA PARAMETER");
//
//***********************************************
//
// VERTICAL FIELD MOBILITY EFFECTS PARAMETERS (4)
//
//***********************************************
//
parameter real		KP 		= 500.0E-06 	from [0.0:inf)		`ATTR(info="MOBILITY (MULTIPLIED BY Cb) PARAMETER");

parameter real		E0 		= 1.0E+10	from (0.0:inf)		`ATTR(info="FIRST ORDER PARAMETER FOR MOBILITY REDUCTION DUE TO VERTICAL FIELD EFFECT");

parameter real		E1 		= 3.1E+08	from (0.0:inf)		`ATTR(info="SECOND ORDER PARAMETER FOR MOBILITY REDUCTION DUE TO VERTICAL FIELD EFFECT");

parameter real		ETA 		= 0.5		from [0.0:inf)		`ATTR(info="INVERSION CHARGE COEFFICIENT FOR VERTICAL FIELD CALCULATION");
//
//***********************************************
//
// COULOMB SCATTERING (2)
//
//***********************************************
//
parameter real		THC 		= 0.0		from [0.0:inf)		`ATTR(info="COULOMB SCATTERING PARAMETER");

parameter real		ZC 		= 1.0E-6	from [0.0:inf)		`ATTR(info="COULOMB SCATTERING INVERSION CHARGE COEFFICIENT");

//
//***********************************************
//
// MOBILITY RELATED GEOMETRICAL PARAMETERS (7)
//
//***********************************************
//
parameter real		LA 	    	= 1.0		from [0.0:inf)		`ATTR(info="CRITICAL LENGTH A OF MOBILITY LENGTH SCALING");

parameter real		LB 		  = 1.0		from [0.0:inf)		`ATTR(info="CRITICAL LENGTH B OF MOBILITY LENGTH SCALING");

parameter real		KA 		  = 0.0		from (-inf:inf)			`ATTR(info="PARAMETER FOR CRITICAL LENGTH A OF MOBILITY LENGTH SCALING");

parameter real		KB 		   = 0.0		from (-inf:inf)			`ATTR(info="PARAMETER FOR CRITICAL LENGTH B OF MOBILITY LENGTH SCALING");

parameter real		WKP1 	   = 1.0E-6	from (-inf:inf)		`ATTR(info="CRITICAL WIDTH OF MOBILITY WIDTH SCALING");

parameter real		WKP2 		= 0.0		from (-inf:inf)		`ATTR(info="AMPLITUDE PARAMETER FOR MOBILITY WIDTH SCALING");

parameter real		WKP3 		= 1.0		from (-inf:inf)		`ATTR(info="SPAN PARAMETER FOR MOBILITY WIDTH SCALING");
//
//***********************************************
//
// GEOMETRICAL PARAMETERS (8)
//
//***********************************************
//
parameter real		DL 		= -10.0E-9	from (-inf:inf)		`ATTR(info="EFFECTIVE LENGTH PARAMETER");

parameter real		DLC 		= 0.0		from (-inf:inf)		`ATTR(info="EFFECTIVE LENGTH PARAMETER FOR DYNAMIC BEHAVIOUR");

parameter real		DW 		= -10.0E-9	from (-inf:inf)		`ATTR(info="EFFECTIVE WIDTH PARAMETER");

parameter real		DWC 		= 0.0		from (-inf:inf)		`ATTR(info="EFFECTIVE WIDTH PARAMETER FOR DYNAMIC BEHAVIOUR");

parameter real		WDL 		= 0.0		from (-inf:inf)		`ATTR(info="EFFECTIVE LENGTH PARAMETER FOR NARROW CHANNEL DEVICES");

parameter real		LDW 		= 0.0		from (-inf:inf)		`ATTR(info="EFFECTIVE WIDTH PARAMETER FOR SHORT CHANNEL DEVICES");

parameter real		LL 		= 0.0		from (-inf:inf)		`ATTR(info="BASE OF EXPONENTIAL MODEL FOR EFFECTIVE LENGTH");

parameter real		LLN 		= 1.0		from (-inf:inf)		`ATTR(info="EXPONENT OF EXPONENTIAL MODEL FOR EFFECTIVE LENGTH");

//
//***********************************************
//
// LONG AND WIDE CHANNEL VTO AND GAMMA CORRECTION (8)
//
//***********************************************
//
parameter real		AVT 		= 0.0		from (-inf:inf)		`ATTR(info="PARAMETER FOR LONG AND WIDE CHANNEL VTO CORRECTION");

parameter real		LVT 		= 1.0		from [0.0:inf)		`ATTR(info="LENGTH FOR LONG AND WIDE CHANNEL VTO CORRECTION");

parameter real		WVT 		= 1.0		from [0.0:inf)		`ATTR(info="WIDTH FOR LONG AND WIDE CHANNEL VTO CORRECTION");

parameter real		AGAM 		= 0.0		from (-inf:inf)		`ATTR(info="PARAMETER FOR LONG AND WIDE CHANNEL GAMMA CORRECTION");

parameter real		LGAM 		= 1.0		from [0.0:inf)		`ATTR(info="LENGTH FOR LONG AND WIDE CHANNEL GAMMA CORRECTION");

parameter real		WGAM 		= 1.0		from [0.0:inf)		`ATTR(info="WIDTH FOR LONG AND WIDE CHANNEL GAMMA CORRECTION");

parameter real 		NFVTA   	= 0.0		from [0.0:inf)		`ATTR(info="NUMBER OF FINGERS FOR VTO CORRECTION FOR MULTIFINGER DEVICES (OBSOLETE MODEL BY STI STRESS EFFECT)");

parameter real 		NFVTB   	= 10000.0	from (-inf:inf)		`ATTR(info="PARAMETER FOR VTO CORRECTION FOR MULTIFINGER DEVICES (OBSOLETE MODEL BY STI STRESS EFFECT)");

//
//***********************************************
//
// VELOCITY SATURATION & CLM RELATED PARAMETERS (4)
//
//***********************************************
//
parameter real		UCRIT 		= 5.0E+06 	from (0.0:inf)		`ATTR(info="CRITICAL VELOCITY OF VELOCITY SATURATION EFFECT");

parameter real		DELTA 		= 2.0		from [1.0:2.0]		`ATTR(info="VARIABLE ORDER (FROM 1.0 TO 2.0) OF VELOCITY SATURATION EFFECT");

parameter real		LAMBDA		= 0.5		from [0.0:inf)		`ATTR(info="LENGTH PARAMETER FOR CHANNEL LENGTH MODULATION");

parameter real		ACLM 		= 0.83		from [0.0:inf)		`ATTR(info="FINE TUNING PARAMETER FOR CHANNEL LENGTH MODULATION");

//
//***********************************************
//
// REVERSE SHORT CHANNEL EFFECT (4)
//
//***********************************************
//
parameter real		LR 		= 50.0E-09 	from (0.0:inf)		`ATTR(info="LENGTH PARAMETER FOR REVERSE SHORT CHANNEL EFFECT");

parameter real		QLR 		= 0.5E-3	from (-inf:inf)		`ATTR(info="CHARGE PARAMETER FOR REVERSE SHORT CHANNEL EFFECT (VTO)");

parameter real		NLR 		= 10.0E-3 	from (-inf:inf)		`ATTR(info="DOPING PARAMETER FOR REVERSE SHORT CHANNEL EFFECT (GAMMA)");

parameter real		FLR		= 1.0 		from [0.0:inf)		`ATTR(info="FERMI POTENTIAL FINE TUNING PARAMETER FOR REVERSE SHORT CHANNEL EFFECT (PHIF)");

//
//***********************************************
//
// CHARGE SHARING EFFECT (5)
//
//***********************************************
//

parameter real		LETA0 		= 0.0		from (-inf:inf)		`ATTR(info="LENGTH INDEPENDENT PARAMETER FOR CHARGE SHARING (LONG CHANNEL)");

parameter real		LETA 		= 500.0E-3 	from [0.0:inf)		`ATTR(info="LENGTH SCALING PARAMETER FOR CHARGE SHARING");

parameter real		LETA2 		= 0.0 		from (-inf:inf)		`ATTR(info="SECOND ORDER LENGTH SCALING PARAMETER FOR CHARGE SHARING (SHORTEST CHANNEL)");

parameter real		WETA 		= 200.0E-3 	from (-inf:inf)		`ATTR(info="WIDTH SCALING PARAMETER FOR CHARGE SHARING");

parameter real		NCS 		= 1.0		from [0.0:inf)		`ATTR(info="WEAK INVERSION SLOPE PARAMETER FOR CHARGE SHARING");

//
//***********************************************
//
// DRAIN INDUCED BARRIER LOWERING (2)
//
//***********************************************
//
parameter real		ETAD 		= 1.0		from [0.0:inf)		`ATTR(info="ETA PARAMETER FOR DRAIN INDUCED BARRIER LOWERING");

parameter real		SIGMAD		= 1.0		from [0.0:inf)		`ATTR(info="SIGMA PARAMETER FOR DRAIN INDUCED BARRIER LOWERING");

//
//***********************************************
//
// INVERSE NARROW CHANNEL EFFECT (3)
//
//***********************************************
//
parameter real		WR 		= 90.0E-09 	from (0.0:inf)		`ATTR(info="WIDTH PARAMETER FOR INVERSE NARROW CHANNEL EFFECT");

parameter real		QWR 		= 0.3E-3	from (-inf:inf)		`ATTR(info="CHARGE PARAMETER FOR INVERSE NARROW CHANNEL EFFECT (VTO)");

parameter real		NWR 		= 5.0E-3	from (-inf:inf)		`ATTR(info="DOPING PARAMETER FOR INVERSE NARROW CHANNEL EFFECT (GAMMA)");

//
//***********************************************
//
// DITS (5)
//
//***********************************************
//
parameter real	 	FPROUT 		= 1.0E6 	from [0.0:inf)		`ATTR(info="OUTPUT RESISTANCE PARAMETER FOR DRAIN INDUCED THRESHOLD SHIFT");

parameter real	 	PDITS 		= 0.0 		from [0.0:inf)		`ATTR(info="PARAMETER FOR DRAIN INDUCED THRESHOLD SHIFT (IF SET TO ZERO THE DITS EFFECT IS DISABLED)");

parameter real	 	PDITSL 		= 0.0 		from [0.0:inf)		`ATTR(info="LENGTH SCALING PARAMETER FOR DRAIN INDUCED THRESHOLD SHIFT");

parameter real	 	PDITSD 		= 1.0 		from [0.0:inf)		`ATTR(info="BIAS PARAMETER FOR DRAIN INDUCED THRESHOLD SHIFT");

parameter real		DDITS		= 0.3 		from [0.0:inf)		`ATTR(info="SMOOTH FACTOR OF OUTPUT CONDUCTANCE FOR DRAIN INDUCED THRESHOLD SHIFT");

//
//***********************************************
//
// IMPACT IONIZATION CURRENT (3)
//
//***********************************************
//
parameter real		IBA 		= 000.0E+06 	from [0.0:inf)		`ATTR(info="PARAMETER A OF IMPACT IONIZATION CURRENT");

parameter real		IBB 		= 300.0E+06 	from [0.0:inf)		`ATTR(info="PARAMETER B OF IMPACT IONIZATION CURRENT");

parameter real		IBN 		= 1.0		from [0.0:inf)		`ATTR(info="PARAMETER N OF IMPACT IONIZATION CURRENT");
//
//***********************************************
//
// GIDL - GISL (4)
//
//***********************************************
//
parameter real 		AGIDL  		= 0.0 		from [0.0:inf)		`ATTR(info="PARAMETER A OF GATE INDUCED DRAIN LEAKAGE");

parameter real 		BGIDL  		= 2.3E+09 	from [0.0:inf)		`ATTR(info="PARAMETER B OF GATE INDUCED DRAIN LEAKAGE");

parameter real 		CGIDL  		= 0.5 		from [0.0:inf)		`ATTR(info="PARAMETER C OF GATE INDUCED DRAIN LEAKAGE");

parameter real 		EGIDL  		= 0.8 		from [0.0:inf)		`ATTR(info="PARAMETER E OF GATE INDUCED DRAIN LEAKAGE");
//
//***********************************************
//
// LENGTH SCALING PARAMETERS (3)
//
//***********************************************
//
parameter real		LWR 		= 0.0		from (-inf:inf)		`ATTR(info="LENGTH SCALING PARAMETER FOR WR");

parameter real		LQWR 		= 0.0		from (-inf:inf)		`ATTR(info="LENGTH SCALING PARAMETER FOR QWR");

parameter real		LNWR 		= 0.0		from (-inf:inf)		`ATTR(info="LENGTH SCALING PARAMETER FOR NWR");

parameter real		LDPHIEDGE 	= 0.0		from (-inf:inf)		`ATTR(info="LENGTH SCALING PARAMETER FOR DPHIEDGE");

parameter real		LDGAMMAEDGE	= 0.0		from (-inf:inf)		`ATTR(info="LENGTH SCALING PARAMETER FOR DGAMMAEDGE");
//
//***********************************************
//
// WIDTH SCALING PARAMETERS (11)
//
//***********************************************
//
parameter real		WLR 		= 0.0		from (-inf:inf)		`ATTR(info="WIDTH SCALING PARAMETER FOR LR");

parameter real		WQLR 		= 0.0		from (-inf:inf)		`ATTR(info="WIDTH SCALING PARAMETER FOR QLR");

parameter real		WNLR 		= 0.0		from (-inf:inf)		`ATTR(info="WIDTH SCALING PARAMETER FOR NLR");

parameter real		WUCRIT		= 0.0		from (-inf:inf)		`ATTR(info="WIDTH SCALING PARAMETER FOR UCRIT");

parameter real		WLAMBDA 	= 0.0		from (-inf:inf)		`ATTR(info="WIDTH SCALING PARAMETER FOR LAMBDA");

parameter real		WETAD 		= 0.0		from (-inf:inf)		`ATTR(info="WIDTH SCALING PARAMETER FOR ETAD");

parameter real		WE0 		= 0.0		from (-inf:inf)		`ATTR(info="WIDTH SCALING PARAMETER FOR E0");

parameter real		WE1 		= 0.0		from (-inf:inf)		`ATTR(info="WIDTH SCALING PARAMETER FOR E1");

parameter real		WRLX		= 0.0		from (-inf:inf)		`ATTR(info="WIDTH SCALING PARAMETER FOR RLX");

parameter real		WUCEX		= 0.0		from (-inf:inf)		`ATTR(info="WIDTH SCALING PARAMETER FOR UCEX");

parameter real		WDPHIEDGE 	= 0.0		from (-inf:inf)		`ATTR(info="WIDTH SCALING PARAMETER FOR DPHIEDGE");

parameter real		WDGAMMAEDGE	= 0.0		from (-inf:inf)		`ATTR(info="WIDTH SCALING PARAMETER FOR DGAMMAEDGE");
//
//***********************************************
//
// COMBINED SCALING PARAMETERS (2)
//
//***********************************************
//
parameter real		WLDPHIEDGE 	= 0.0		from (-inf:inf)		`ATTR(info="FINE TUNING SCALING FOR COMBINED SHORT AND NARROW DEVICES FOR DPHIEDGE");

parameter real		WLDGAMMAEDGE 	= 0.0		from (-inf:inf)		`ATTR(info="FINE TUNING SCALING FOR COMBINED SHORT AND NARROW DEVICES FOR DGAMMAEDGE");
//
//***********************************************
//
// EDGE DEVICE (3)
//
//***********************************************
//
parameter real 		WEDGE 		= 0.0		from [0.0:inf)		`ATTR(info="TOTAL EFFECTIVE WIDTH OF EDGE DEVICE FOR EDGE CONDUCTANCE EFFECT");

parameter real 		DGAMMAEDGE 	= 0.0		from (-inf:inf)		`ATTR(info="DIFFERENTIAL GAMMA PARAMETER OF EDGE DEVICE WITH RESPECT TO THE MAIN DEVICE");

parameter real 		DPHIEDGE 	= 0.0		from (-inf:inf)		`ATTR(info="DIFFERENTIAL PHI PARAMETER OF EDGE DEVICE WITH RESPECT TO THE MAIN DEVICE");

//
//***********************************************
//
// TEMPERATURE PARAMETERS (8) //
//
//***********************************************
//
parameter real		TCV 		= 600.0E-6 	from (-inf:inf)		`ATTR(info="TEMPERATURE SCALING OF THRESHOLD VOLTAGE");

parameter real		BEX 		= -1.5		from (-inf:inf)		`ATTR(info="TEMPERATURE SCALING OF MOBILITY");

parameter real		TE0EX 		= 0.5		from (-inf:inf)		`ATTR(info="TEMPERATURE SCALING OF E0");

parameter real		TE1EX 		= 0.5		from (-inf:inf)		`ATTR(info="TEMPERATURE SCALING OF E1");

parameter real		TETA 		= -0.9E-3 	from (-inf:inf)		`ATTR(info="TEMPERATURE SCALING OF ETA PARAMETER");

parameter real		UCEX 		= 1.5		from (-inf:inf)		`ATTR(info="TEMPERATURE SCALING OF CRITICAL VELOCITY OF VELOCITY SATURATION EFFECT");

parameter real		TLAMBDA 	= 0.0		from (-inf:inf)		`ATTR(info="TEMPERATURE SCALING OF LAMBDA PARAMETER");

parameter real		IBBT 		= 800.0E-6 	from (-inf:inf)		`ATTR(info="TEMPERATURE SCALING OF IBB");
//
//***********************************************
//
// TEMPERATURE AND GEOMETRY SCALING (3)
//
//***********************************************
//
parameter real		TCVL 		= 0.0		from (-inf:inf)		`ATTR(info="LENGTH SCALING OF TCV");

parameter real		TCVW 		= 0.0		from (-inf:inf)		`ATTR(info="WIDTH SCALING OF TCV");

parameter real		TCVWL 		= 0.0		from (-inf:inf)		`ATTR(info="AREA SCALING OF TCV");

//
//***********************************************
//
// EXTRINSIC PART //
//
//***********************************************
//
//***********************************************
//
// OVERLAP CAPACITANCES (8)
//
//***********************************************
//
parameter real		GAMMAOV 	= 1.6	 	from (0.0:inf)		`ATTR(info="BODY EFFECT COEFFICIENT OF THE GATE OVERLAP REGION");

parameter real		GAMMAGOV	= 10.0	 	from (0.0:inf)		`ATTR(info="GATE DOPING COEFFICIENT FOR POLYSILICON DEPLETION EFFECT OF THE GATE OVERLAP REGION");

parameter real		VFBOV		= 0.0	 	from (-inf:inf)		`ATTR(info="FLAT-BAND VOLTAGE OF THE GATE OVERLAP REGION");

parameter real		LOV 		= 20.0E-9 	from [0.0:inf)		`ATTR(info="EFFECTIVE LENGTH OF THE GATE OVERLAP REGION");

parameter real		VOV 		= 1.0	 	from [0.0:1.0]		`ATTR(info="BIAS PARAMETER OF THE OVERLAP CAPACITANCES");

parameter real 		CGSO 		= 0.0 		from [0.0:inf)		`ATTR(info="BIAS-INDEPENDENT OVERLAP CAPACITANCE PER GATE WIDTH UNIT BETWEEN GATE AND SOURCE");

parameter real 		CGDO 		= 0.0 		from [0.0:inf)		`ATTR(info="BIAS-INDEPENDENT OVERLAP CAPACITANCE PER GATE WIDTH UNIT BETWEEN GATE AND DRAIN");

parameter real 		CGBO 		= 0.0 		from [0.0:inf)		`ATTR(info="BIAS-INDEPENDENT OVERLAP CAPACITANCE PER GATE LENGTH UNIT BETWEEN GATE AND BULK");
//
//***********************************************
//
// FRINGING CAPACITANCE (4)
//
//***********************************************
//
parameter real		KJF		= 0.0		from [0.0:inf)		`ATTR(info="FRINGING CAPACITANCE PARAMETER");

parameter real		CJF		= 0.0		from [0.0:inf)		`ATTR(info="BIAS SCALING OF FRINGING CAPACITANCE");

parameter real 		VFR 		= 0.0		from [0.0:inf)		`ATTR(info="BUILT-IN VOLTAGE FINE TUNING FOR FRINGING CAPACITANCE MODEL");

parameter real 		DFR 		= 1.0E-3	from [0.0:inf)		`ATTR(info="SMOOTH PARAMETER OF FRINGING CAPACITANCE MODEL");
//
//***********************************************
//
// SERIES RESISTANCES RS AND RD
//
//***********************************************
//
// - TYPICAL SPICE MODEL

parameter real		HDIF 		= 0.0e-6	from [0.0:inf)		`ATTR(info="HALF LENGTH OF THE ACTIVE AREA");

parameter real		RSH 		= 0.0	 	from [0.0:inf)		`ATTR(info="SQUARE RESISTANCE OF ACTIVE AREA");

parameter real		LDIF 		= 0.0	 	from [0.0:inf)		`ATTR(info="DISTANCE BETWEEN THE MIDDLE OF THE ACTIVE AREA AND THE START OF THE CHANNEL");

parameter real		RS 		= 0.0	 	from [0.0:inf)		`ATTR(info="LDD SOURCE SERIES RESISTANCE");

parameter real		RD 		= 0.0	 	from [0.0:inf)		`ATTR(info="LDD DRAIN SERIES RESISTANCE");

// - NON-GEOMETRICAL APPROACH

parameter real		RLX 		= -1.0	 	from (-inf:inf)		`ATTR(info="EXTERNAL SERIES RESISTANCE PER WIDTH UNIT");

parameter real		RSX 		= -1.0	 	from (-inf:inf)		`ATTR(info="EXTERNAL SERIES RESISTANCE PER WIDTH UNIT, SOURCE SIDE (ASYMMETRIC MODEL)");

parameter real		RDX 		= -1.0	 	from (-inf:inf)		`ATTR(info="EXTERNAL SERIES RESISTANCE PER WIDTH UNIT, DRAIN SIDE (ASYMMETRIC MODEL)");

// - TEMPERATURE SCALING

parameter real		TR 		= 0.0	 	from (-inf:inf)		`ATTR(info="FIRST ORDER RESISTANCE TEMPERATURE SCALING PARAMETER");

parameter real		TR2 		= 0.0	 	from (-inf:inf)		`ATTR(info="SECOND ORDER RESISTANCE TEMPERATURE SCALING PARAMETER");

// JUNCTION DRAIN - BULK AND SOURCE-BULK AREA, CURRENT, CAPACITANCE

parameter real		GMIN 		= 0.0	 	from [0.0:inf)		`ATTR(info="MINIMUM CONDUCTANCE OF JUNCTION DIODES");

//
//***********************************************
//
// SOURCE SIDE
//
//***********************************************
//
parameter real		NJS 		= 1.0	 	from (-inf:inf)		`ATTR(info="SLOPE FACTOR FOR JUNCTION DIODE, SOURCE SIDE (ASYMMETRICAL MODEL)");

parameter real		XJBVS 		= 0.0	 	from (-inf:inf)		`ATTR(info="BREAK-DOWN EFFECT COEFFICIENT FOR JUNCTION DIODE, SOURCE SIDE (ASYMMETRICAL MODEL)");

parameter real		BVS 		= 10.0	 	from (-inf:inf)		`ATTR(info="BREAK-DOWN VOLTAGE FOR JUNCTION DIODE, SOURCE SIDE (ASYMMETRICAL MODEL)");

parameter real		JSS 		= 0.0E-09 	from (-inf:inf)		`ATTR(info="AREA COMPONENT OF CURRENT FOR JUNCTION DIODE, SOURCE SIDE (ASYMMETRICAL MODEL)");

parameter real		JSSWS 		= 0.0E-12 	from (-inf:inf)		`ATTR(info="SIDEWAYS COMPONENT OF CURRENT FOR JUNCTION DIODE, SOURCE SIDE (ASYMMETRICAL MODEL)");

parameter real		JSSWGS 		= 0.0E-12 	from (-inf:inf)		`ATTR(info="GATE-SIDE COMPONENT OF CURRENT FOR JUNCTION DIODE, SOURCE SIDE (ASYMMETRICAL MODEL)");

parameter real		JTSS 		= 0.0E-09 	from (-inf:inf)		`ATTR(info="AREA COMPONENT OF TRAP-ASSISTED CURRENT FOR JUNCTION DIODE, SOURCE SIDE (ASYMMETRICAL MODEL)");

parameter real		JTSSWS 		= 0.0E-12 	from (-inf:inf)		`ATTR(info="SIDEWAYS COMPONENT OF TRAP-ASSISTED CURRENT FOR JUNCTION DIODE, SOURCE SIDE (ASYMMETRICAL MODEL)");

parameter real		JTSSWGS 	= 0.0E-12 	from (-inf:inf)		`ATTR(info="GATESIDE COMPONENT OF TRAP-ASSISTED CURRENT FOR JUNCTION DIODE, SOURCE SIDE (ASYMMETRICAL MODEL)");

parameter real		NJTSS 		= 1.0	 	from (-inf:inf)		`ATTR(info="AREA SLOPE FACTOR OF TRAP-ASSISTED CURRENT FOR JUNCTION DIODE, SOURCE SIDE (ASYMMETRICAL MODEL)");

parameter real		NJTSSWS		= 1.0	 	from (-inf:inf)		`ATTR(info="SIDEWAYS SLOPE FACTOR OF TRAP-ASSISTED CURRENT FOR JUNCTION DIODE, SOURCE SIDE (ASYMMETRICAL MODEL)");

parameter real		NJTSSWGS	= 1.0	 	from (-inf:inf)		`ATTR(info="GATESIDE SLOPE FACTOR OF TRAP-ASSISTED CURRENT FOR JUNCTION DIODE, SOURCE SIDE (ASYMMETRICAL MODEL)");

parameter real		VTSS		= 0.0	 	from (-inf:inf)		`ATTR(info="AREA VOLTAGE FACTOR OF TRAP-ASSISTED CURRENT FOR JUNCTION DIODE, SOURCE SIDE (ASYMMETRICAL MODEL)");

parameter real		VTSSWS 		= 0.0	 	from (-inf:inf)		`ATTR(info="SIDEWAYS VOLTAGE FACTOR OF TRAP-ASSISTED CURRENT FOR JUNCTION DIODE, SOURCE SIDE (ASYMMETRICAL MODEL)");

parameter real		VTSSWGS		= 0.0	 	from (-inf:inf)		`ATTR(info="GATESIDE VOLTAGE FACTOR OF TRAP-ASSISTED CURRENT FOR JUNCTION DIODE, SOURCE SIDE (ASYMMETRICAL MODEL)");

parameter real		CJS 		= 0.0E-06 	from (-inf:inf)		`ATTR(info="AREA COMPONENT OF CAPACITANCE FOR JUNCTION DIODE, SOURCE SIDE (ASYMMETRICAL MODEL)");

parameter real		CJSWS 		= 0.0E-09 	from (-inf:inf)		`ATTR(info="SIDEWAYS COMPONENT OF CAPACITANCE FOR JUNCTION DIODE, SOURCE SIDE (ASYMMETRICAL MODEL)");

parameter real		CJSWGS 		= 0.0E-09 	from (-inf:inf)		`ATTR(info="GATESIDE COMPONENT OF CAPACITANCE FOR JUNCTION DIODE, SOURCE SIDE (ASYMMETRICAL MODEL)");

parameter real		PBS 		= 0.800	 	from (-inf:inf)		`ATTR(info="AREA PARAMETER OF CAPACITANCE FOR JUNCTION DIODE, SOURCE SIDE (ASYMMETRICAL MODEL)");

parameter real		PBSWS 		= 0.600	 	from (-inf:inf)		`ATTR(info="SIDEWAYS PARAMETER OF CAPACITANCE FOR JUNCTION DIODE, SOURCE SIDE (ASYMMETRICAL MODEL)");

parameter real		PBSWGS 		= 0.600	 	from (-inf:inf)		`ATTR(info="GATESIDE PARAMETER OF CAPACITANCE FOR JUNCTION DIODE, SOURCE SIDE (ASYMMETRICAL MODEL)");

parameter real		MJS 		= 0.900	 	from (-inf:inf)		`ATTR(info="AREA EXPONENT OF CAPACITANCE FOR JUNCTION DIODE, SOURCE SIDE (ASYMMETRICAL MODEL)");

parameter real		MJSWS 		= 0.700	 	from (-inf:inf)		`ATTR(info="SIDEWAYS EXPONENT OF CAPACITANCE FOR JUNCTION DIODE, SOURCE SIDE (ASYMMETRICAL MODEL)");

parameter real		MJSWGS 		= 0.700	 	from (-inf:inf)		`ATTR(info="GATESIDE EXPONENT OF CAPACITANCE FOR JUNCTION DIODE, SOURCE SIDE (ASYMMETRICAL MODEL)");

parameter real		XTIS 		= 3.0	 	from (-inf:inf)		`ATTR(info="TEMPERATURE DEPENDENCE FOR JUNCTION DIODE, SOURCE SIDE (ASYMMETRICAL MODEL)");

parameter real		XTSS 		= 0.0		from (-inf:inf)		`ATTR(info="AREA COMPONENT OF TEMPERATURE DEPENDENCE OF TRAP-ASSISTED CURRENT FOR JUNCTION DIODE, SOURCE SIDE (ASYMMETRICAL MODEL)");

parameter real		XTSSWS 		= 0.0		from (-inf:inf)		`ATTR(info="SIDEWAYS COMPONENT OF TEMPERATURE DEPENDENCE OF TRAP-ASSISTED CURRENT FOR JUNCTION DIODE, SOURCE SIDE (ASYMMETRICAL MODEL)");

parameter real		XTSSWGS		= 0.0		from (-inf:inf)		`ATTR(info="GATESIDE COMPONENT OF TEMPERATURE DEPENDENCE OF TRAP-ASSISTED CURRENT FOR JUNCTION DIODE, SOURCE SIDE (ASYMMETRICAL MODEL)");

parameter real		TNJTSS 		= 0.0	 	from (-inf:inf)		`ATTR(info="TEMPERATURE DEPENDENCE OF NJTSS (AREA), JUNCTION DIODE, SOURCE SIDE (ASYMMETRICAL MODEL)");

parameter real		TNJTSSWS	= 0.0	 	from (-inf:inf)		`ATTR(info="TEMPERATURE DEPENDENCE OF NJTSSWS (SIDEWAYS), JUNCTION DIODE, SOURCE SIDE (ASYMMETRICAL MODEL)");

parameter real		TNJTSSWGS	= 0.0	 	from (-inf:inf)		`ATTR(info="TEMPERATURE DEPENDENCE OF NJTSSWGS (GATESIDE), JUNCTION DIODE, SOURCE SIDE (ASYMMETRICAL MODEL)");
//
//***********************************************
//
// BOTH SIDES
//
//***********************************************
//
parameter real		TCJ 		= 0.0	 	from (-inf:inf)		`ATTR(info="TEMPERATURE DEPENDENCE OF AREA COMPONENT OF CAPACITANCE FOR JUNCTION DIODES (CJS AND CJD), BOTH (SOURCE AND DRAIN) SIDES (ASYMMETRICAL MODEL)");

parameter real		TCJSW 		= 0.0	 	from (-inf:inf)		`ATTR(info="TEMPERATURE DEPENDENCE OF SIDEWAYS COMPONENT OF CAPACITANCE FOR JUNCTION DIODES (CJSWS AND CJSWD), BOTH (SOURCE AND DRAIN) SIDES (ASYMMETRICAL MODEL)");

parameter real		TCJSWG 		= 0.0	 	from (-inf:inf)		`ATTR(info="TEMPERATURE DEPENDENCE OF GATESIDE COMPONENT OF CAPACITANCE FOR JUNCTION DIODES (CJSWGS AND CJSWGD), BOTH (SOURCE AND DRAIN) SIDES (ASYMMETRICAL MODEL)");

parameter real		TPB 		= 0.0	 	from (-inf:inf)		`ATTR(info="TEMPERATURE DEPENDENCE OF AREA PARAMETER OF CAPACITANCE FOR JUNCTION DIODES (PBS AND PBD), BOTH (SOURCE AND DRAIN) SIDES (ASYMMETRICAL MODEL)");

parameter real		TPBSW 		= 0.0	 	from (-inf:inf)		`ATTR(info="TEMPERATURE DEPENDENCE OF SIDEWAYS PARAMETER OF CAPACITANCE FOR JUNCTION DIODES (PBSWS AND PBSWD), BOTH (SOURCE AND DRAIN) SIDES (ASYMMETRICAL MODEL)");

parameter real		TPBSWG 		= 0.0	 	from (-inf:inf)		`ATTR(info="TEMPERATURE DEPENDENCE OF GATESIDE PARAMETER OF CAPACITANCE FOR JUNCTION DIODES (PBSWGS AND PBSWGD), BOTH (SOURCE AND DRAIN) SIDES (ASYMMETRICAL MODEL)");
//
//***********************************************
//
// DRAIN SIDE
//
//***********************************************
//
parameter real		NJD 		= 1.0	 	from (-inf:inf)		`ATTR(info="SLOPE FACTOR FOR JUNCTION DIODE, DRAIN SIDE (ASYMMETRICAL MODEL)");

parameter real		XJBVD 		= 0.0	 	from (-inf:inf)		`ATTR(info="BREAK-DOWN EFFECT COEFFICIENT FOR JUNCTION DIODE, DRAIN SIDE (ASYMMETRICAL MODEL)");

parameter real		BVD 		= 10.0	 	from (-inf:inf)		`ATTR(info="BREAK-DOWN VOLTAGE FOR JUNCTION DIODE, DRAIN SIDE (ASYMMETRICAL MODEL)");

parameter real		JSD 		= 0.0E-09 	from (-inf:inf)		`ATTR(info="AREA COMPONENT OF CURRENT FOR JUNCTION DIODE, DRAIN SIDE (ASYMMETRICAL MODEL)");

parameter real		JSSWD 		= 0.0E-12 	from (-inf:inf)		`ATTR(info="SIDEWAYS COMPONENT OF CURRENT FOR JUNCTION DIODE, DRAIN SIDE (ASYMMETRICAL MODEL)");

parameter real		JSSWGD 		= 0.0E-12 	from (-inf:inf)		`ATTR(info="GATE-SIDE COMPONENT OF CURRENT FOR JUNCTION DIODE, DRAIN SIDE (ASYMMETRICAL MODEL)");

parameter real		JTSD 		= 0.0E-09 	from (-inf:inf)		`ATTR(info="AREA COMPONENT OF TRAP-ASSISTED CURRENT FOR JUNCTION DIODE, DRAIN SIDE (ASYMMETRICAL MODEL)");

parameter real		JTSSWD 		= 0.0E-12 	from (-inf:inf)		`ATTR(info="SIDEWAYS COMPONENT OF TRAP-ASSISTED CURRENT FOR JUNCTION DIODE, DRAIN SIDE (ASYMMETRICAL MODEL)");

parameter real		JTSSWGD 	= 0.0E-12 	from (-inf:inf)		`ATTR(info="GATESIDE COMPONENT OF TRAP-ASSISTED CURRENT FOR JUNCTION DIODE, DRAIN SIDE (ASYMMETRICAL MODEL)");

parameter real		NJTSD 		= 1.0	 	from (-inf:inf)		`ATTR(info="AREA SLOPE FACTOR OF TRAP-ASSISTED CURRENT FOR JUNCTION DIODE, DRAIN SIDE (ASYMMETRICAL MODEL)");

parameter real		NJTSSWD		= 1.0	 	from (-inf:inf)		`ATTR(info="SIDEWAYS SLOPE FACTOR OF TRAP-ASSISTED CURRENT FOR JUNCTION DIODE, DRAIN SIDE (ASYMMETRICAL MODEL)");

parameter real		NJTSSWGD	= 1.0	 	from (-inf:inf)		`ATTR(info="GATESIDE SLOPE FACTOR OF TRAP-ASSISTED CURRENT FOR JUNCTION DIODE, DRAIN SIDE (ASYMMETRICAL MODEL)");

parameter real		VTSD		= 0.0	 	from (-inf:inf)		`ATTR(info="AREA VOLTAGE FACTOR OF TRAP-ASSISTED CURRENT FOR JUNCTION DIODE, DRAIN SIDE (ASYMMETRICAL MODEL)");

parameter real		VTSSWD 		= 0.0	 	from (-inf:inf)		`ATTR(info="SIDEWAYS VOLTAGE FACTOR OF TRAP-ASSISTED CURRENT FOR JUNCTION DIODE, DRAIN SIDE (ASYMMETRICAL MODEL)");

parameter real		VTSSWGD		= 0.0	 	from (-inf:inf)		`ATTR(info="GATESIDE VOLTAGE FACTOR OF TRAP-ASSISTED CURRENT FOR JUNCTION DIODE, DRAIN SIDE (ASYMMETRICAL MODEL)");

parameter real		CJD 		= 0.0E-06 	from (-inf:inf)		`ATTR(info="AREA COMPONENT OF CAPACITANCE FOR JUNCTION DIODE, DRAIN SIDE (ASYMMETRICAL MODEL)");

parameter real		CJSWD 		= 0.0E-09 	from (-inf:inf)		`ATTR(info="SIDEWAYS COMPONENT OF CAPACITANCE FOR JUNCTION DIODE, DRAIN SIDE (ASYMMETRICAL MODEL)");

parameter real		CJSWGD 		= 0.0E-09 	from (-inf:inf)		`ATTR(info="GATESIDE COMPONENT OF CAPACITANCE FOR JUNCTION DIODE, DRAIN SIDE (ASYMMETRICAL MODEL)");

parameter real		PBD 		= 0.800	 	from (-inf:inf)		`ATTR(info="AREA PARAMETER OF CAPACITANCE FOR JUNCTION DIODE, DRAIN SIDE (ASYMMETRICAL MODEL)");

parameter real		PBSWD 		= 0.600	 	from (-inf:inf)		`ATTR(info="SIDEWAYS PARAMETER OF CAPACITANCE FOR JUNCTION DIODE, DRAIN SIDE (ASYMMETRICAL MODEL)");

parameter real		PBSWGD 		= 0.600	 	from (-inf:inf)		`ATTR(info="GATESIDE PARAMETER OF CAPACITANCE FOR JUNCTION DIODE, DRAIN SIDE (ASYMMETRICAL MODEL)");

parameter real		MJD 		= 0.900	 	from (-inf:inf)		`ATTR(info="AREA EXPONENT OF CAPACITANCE FOR JUNCTION DIODE, DRAIN SIDE (ASYMMETRICAL MODEL)");

parameter real		MJSWD 		= 0.700	 	from (-inf:inf)		`ATTR(info="SIDEWAYS EXPONENT OF CAPACITANCE FOR JUNCTION DIODE, DRAIN SIDE (ASYMMETRICAL MODEL)");

parameter real		MJSWGD 		= 0.700	 	from (-inf:inf)		`ATTR(info="GATESIDE EXPONENT OF CAPACITANCE FOR JUNCTION DIODE, DRAIN SIDE (ASYMMETRICAL MODEL)");

parameter real		XTID 		= 3.0	 	from (-inf:inf)		`ATTR(info="TEMPERATURE DEPENDENCE FOR JUNCTION DIODE, DRAIN SIDE (ASYMMETRICAL MODEL)");

parameter real		XTSD 		= 0.0		from (-inf:inf)		`ATTR(info="AREA COMPONENT OF TEMPERATURE DEPENDENCE OF TRAP-ASSISTED CURRENT FOR JUNCTION DIODE, DRAIN SIDE (ASYMMETRICAL MODEL)");

parameter real		XTSSWD 		= 0.0		from (-inf:inf)		`ATTR(info="SIDEWAYS COMPONENT OF TEMPERATURE DEPENDENCE OF TRAP-ASSISTED CURRENT FOR JUNCTION DIODE, DRAIN SIDE (ASYMMETRICAL MODEL)");

parameter real		XTSSWGD		= 0.0		from (-inf:inf)		`ATTR(info="GATESIDE COMPONENT OF TEMPERATURE DEPENDENCE OF TRAP-ASSISTED CURRENT FOR JUNCTION DIODE, DRAIN SIDE (ASYMMETRICAL MODEL)");

parameter real		TNJTSD 		= 0.0	 	from (-inf:inf)		`ATTR(info="TEMPERATURE DEPENDENCE OF NJTSS (AREA), JUNCTION DIODE, DRAIN SIDE (ASYMMETRICAL MODEL)");

parameter real		TNJTSSWD	= 0.0	 	from (-inf:inf)		`ATTR(info="TEMPERATURE DEPENDENCE OF NJTSSWS (SIDEWAYS), JUNCTION DIODE, DRAIN SIDE (ASYMMETRICAL MODEL)");

parameter real		TNJTSSWGD	= 0.0	 	from (-inf:inf)		`ATTR(info="TEMPERATURE DEPENDENCE OF NJTSSWGS (GATESIDE), JUNCTION DIODE, DRAIN SIDE (ASYMMETRICAL MODEL)");

//
//***********************************************
//// ACCESS REGION GEOMETRY
//
//***********************************************
//

parameter real       LARD = 7.0E-6             from [0.0:inf)       `ATTR(type="instance" info="DRAIN ACCESS REGION LENGTH");

parameter real       LARS = 2.0E-6             from [0.0:inf)       `ATTR(type="instance" info="SOURCE ACCESS REGION LENGTH");

parameter real       LGD = 10.0E-6              from [0.0:inf)       `ATTR(type="instance" info="GATE-TO-DRAIN SPACING");

parameter real       LGS = 2.0E-6               from [0.0:inf)       `ATTR(type="instance" info="GATE-TO-SOURCE SPACING");

//
//***********************************************
//
// MATERIAL AND PHYSICAL PARAMETERS
//
//***********************************************
//
parameter real       LGS = 2.0E-6                    from [0.0:inf)          `ATTR(type="instance" info="GATE-TO-SOURCE SPACING");

parameter real       EP_GAN = 8.9*EP0              from (0.0:inf)     `ATTR(info="RELATIVE PERMITTIVITY OF GaN");

parameter real       NC_GAN = (2.3E18)*(1E6)    from [0.0:inf)         `ATTR(info="EFFECTIVE CONDUCTION BAND DENSITY OF STATES FOR GaN [1/m^3]");

parameter real       NV_GAN = (1.89E19)*(1E6)    from [0.0:inf)        `ATTR(info="EFFECTIVE VALENCE BAND DENSITY OF STATES FOR GaN [1/m^3]");

parameter real       NC_ALGAN = (3.5E18)*(1E6)  from [0.0:inf)         `ATTR(info="EFFECTIVE CONDUCTION BAND DENSITY OF STATES FOR AlGaN [1/m^3]");

parameter real       NV_ALGAN = (1.3E19)*(1E6)   from [0.0:inf)        `ATTR(info="EFFECTIVE VALENCE BAND DENSITY OF STATES FOR AlGaN [1/m^3]");

parameter real       NDEP = (1.0E13)*(1E6)           from [0.0:inf)        `ATTR(info="CHANNEL DOPING CONCENTRATION [1/m^3]");

parameter real       CIT = 0.0                            from [0.0:inf)         `ATTR(info="INTERFACE TRAP DENSITY");

//
//***********************************************
//// DIBL AND SUBTHRESHOLD PARAMETERS
//
//***********************************************
//

parameter real       ETA0 = 0.03                       from (-inf:inf)        `ATTR(info="DRAIN-INDUCED BARRIER LOWERING COEFFICIENT");

parameter real       ETAB = -0.01                      from (-inf:inf)         `ATTR(info="BODY-BIAS COEFFICIENT FOR DIBL");

parameter real       PHIN = 0.045                     from (-inf:inf)         `ATTR(info="NONUNIFORM VERTICAL DOPING COEFFICIENT");

parameter real       NFACTOR = 0.0                   from [0.0:inf)          `ATTR(info="SUBTHRESHOLD SLOPE FACTOR");

parameter real       CDSCD = 1.0E-9                   from [0.0:inf)           `ATTR(info="DRAIN-BIAS SENSITIVITY OF SUBTHRESHOLD SLOPE");

parameter real       CDSCB = 0.0                       from [0.0:inf)           `ATTR(info="BODY-BIAS SENSITIVITY OF SUBTHRESHOLD SLOPE");

parameter real       GG = 1.6E-12                     from [0.0:inf)           `ATTR(info="QUANTUM CHARGE POTENTIAL COEFFICIENT");

//
//***********************************************
//
// MOBILITY MODEL PARAMETERS
//
//***********************************************
//

parameter real       U0 = 0.165                         from (0.0)               `ATTR(info="LOW-FIELD MOBILITY");

parameter real       UA = 3.0                           from [0.0:inf)           `ATTR(info="VERTICAL-FIELD MOBILITY DEGRADATION COEFFICIENT");

parameter real       UC = 0.0                           from [0.0:inf)           `ATTR(info="BODY-BIAS MOBILITY DEGRADATION COEFFICIENT");

parameter real       UD = 37.0                        from [0.0:inf)           `ATTR(info="COULOMB SCATTERING COEFFICIENT");

parameter real       EU = 1.0                          from [0.0:inf)            `ATTR(info="MOBILITY DEGRADATION EXPONENT");

parameter real       DE0 = -1.0                       from (-inf:inf)            `ATTR(info="VERTICAL-FIELD MOBILITY POWER FACTOR");

parameter real       ETAVSAT = 0.5                from (-inf:inf)            `ATTR(info="TEMPERATURE COEFFICIENT OF SATURATION VELOCITY");

parameter real       USC = 1.0                        from [0.0:inf)            `ATTR(info="COULOMB SCATTERING SCALING COEFFICIENT");

parameter real       AVDSX = 40.0                  from [5.0:100.0]        `ATTR(info="SMOOTHING PARAMETER FOR EFFECTIVE DRAIN VOLTAGE");

parameter real       LC = 10.0E-9                  from (0.0)                 `ATTR(info="CHARACTERISTIC LENGTH PARAMETER");

parameter real       PTWG = 0.0                    from [0.0:inf)            `ATTR(info="GATE-VOLTAGE COEFFICIENT FOR CHANNEL LENGTH MODULATION");

//
//***********************************************
//// DEVICE TYPE PARAMETERS
//
//***********************************************
//

parameter integer TYPE = type_n                from [-1:1]                 `ATTR(info="DEVICE POLARITY: NFET=1, PFET=-1");

//
//***********************************************
//// SELF-HEATING PARAMETERS
//
//***********************************************
//
parameter real        RTH = 30.0                 from [0.0:inf)             `ATTR(info="THERMAL RESISTANCE [K/W]");

parameter real       CTH = 1.0E-9               from [0.0:inf)              `ATTR(info="THERMAL CAPACITANCE [J/K]");

//
//***********************************************
//
// ACCESS REGION TRANSPORT
//
//***********************************************
//

parameter real     NS0 = 5.0E17*25.0        from [0.0:inf)               `ATTR(info="ACCESS REGION SHEET CHARGE DENSITY");

parameter real     MU0ACC = 0.165           from [0.0:inf)               `ATTR(info="LOW-FIELD ACCESS REGION MOBILITY");

parameter real     VSAT0ACC = 5.0E4       from [0.0:inf)               `ATTR(info="ACCESS REGION SATURATION VELOCITY");

parameter real     RCS = 1.0E-4               from [0.0:inf)               `ATTR(info="SOURCE CONTACT RESISTANCE");

parameter real     RCD = 1.0E-4               from [0.0:inf)               `ATTR(info="DRAIN CONTACT RESISTANCE");

parameter real     KTRS = 0.0                  from [0.0:inf)               `ATTR(info="SOURCE CONTACT TEMPERATURE COEFFICIENT");

parameter real     KTRD = 0.0                 from [0.0:inf)               `ATTR(info="DRAIN CONTACT TEMPERATURE COEFFICIENT");

parameter real     KTH1 = 0.0                 from  [0.0:inf)              `ATTR(info="FIRST-ORDER SELF-HEATING COEFFICIENT");

parameter real     KTH2 = 0.0                from [0.0:inf)               `ATTR(info="SECOND-ORDER SELF-HEATING COEFFICIENT");

parameter real     KTH3 = 0.0                from (-inf:inf)               `ATTR(info="THIRD-ORDER SELF-HEATING COEFFICIENT");

parameter real     GSAR = 2.2                from (-inf:inf)               `ATTR(info="ACCESS REGION GEOMETRY SCALING FACTOR");

//
//***********************************************
//// FIELD-PLATE PARAMETERS
//
//***********************************************
//
parameter integer   FLAGFP1 = 1            from [0:1]                   `ATTR(info="FIELD-PLATE ENABLE FLAG");

parameter real       LGFP1 = 2.0E-6        from [0.0:inf)              `ATTR(info="FIELD-PLATE LENGTH");

parameter real       VTOFP1 = -35.3        from (-inf:inf)             `ATTR(info="FIELD-PLATE THRESHOLD VOLTAGE");

parameter real       CBFP1 = 0.0              from [0.0:inf)             `ATTR(info="FIELD-PLATE  CAPACITANCE PER UNIT WIDTH");

//
//***********************************************
//
// NUMERICAL LIMIT PARAMETERS
//
//***********************************************
//

parameter real      MINL = 1.0E-9          from [0.0:inf)              `ATTR(info="MINIMUM EFFECTIVE LENGTH");

parameter real      MINC = 1.0E-15        from [0.0:inf)               `ATTR(info="MINIMUM CAPACITANCE");

parameter real      MINR = 1.0E-3         from [0.0:inf)               `ATTR(info="MINIMUM RESISTANCE");

//
//***********************************************
//// GATE RESISTANCE PARAMETERS
//
//***********************************************
//

parameter real        RGSP = 0.0    from [0.0:inf)     `ATTR(info="GATE RESISTANCE MULTIPLIED BY WIDTH");
parameter real    L    	         = 1E-6 	    from [0.0:inf]; // Channel length [m]
parameter real    Lard    	     = 7.0E-6 	    from [0.0:inf]; // Channel length [m]
parameter real    Lars    	     = 2.0E-6 	    from [0.0:inf]; // Channel length [m]
parameter real    lgd    	     = 10.0E-6 	    from [0.0:inf]; // Channel length [m]
parameter real    lgs    	     = 2.0E-6 	    from [0.0:inf]; // Channel length [m]
parameter real    W    	     = 3000E-6 	    from [0.0:inf]; // Channel width [m]
parameter real    NF    	     = 1 	              from [1:inf]; // Number of Figures
parameter real    x1         = 30e-9                  from (0:inf);  // AlGaN Layer Thickness (with negative sign)
parameter real    TNOM       = 300  	             from [0.0:inf]; // Temperature [K]
//parameter real    VA             = -5.43          from[-inf:inf];       // V             Threshold Voltage
parameter real    vto             = -3.9                   from[-inf:inf];       // V             Threshold Voltage
parameter real   ep_GaN             =8.9*`EP0        from[-inf:inf];
parameter real    NC_GaN =(2.3e18)*(1e6)     from[-inf:inf];
parameter real    NV=(1.89e19)*(1e6)            from[-inf:inf];
parameter real    NC=(3.5e18)*(1e6)             from[-inf:inf];
parameter real    NV_AlGaN=(1.3e19)*(1e6)    from[-inf:inf];
parameter real     pi = 3.14159                      from[-inf:inf];
parameter real     q = 1.602e-19                    from[-inf:inf];
parameter real     me = 9.11e-31   from[-inf:inf];
parameter real    ETA0             = 0.03          from[-inf:inf];       //                DIBL Coefficeint
parameter real    ETAB             = -0.01          from[-inf:inf];       // 1/V             Body Bias coefficent for DIBL Subthreshold
parameter real    PHIN             = 0.045          from[-inf:inf];       // V             Non uniform vertical doping effect on surface
parameter real    NDEP            = (1.0e13)*(1e6)  from (0.0:inf);      //"1/m^3"   Doping of GaN layer
parameter real    xx         = 0.3          from (0.0:1);   // percentage of Al in AlxxGa(1-xx)N
parameter real    gg      =1.6e-12	    from [0.0:inf];  //Quantum charge potential coefficent
parameter real    E0 	     = 2.0e8; 	    	 	    // Vertical Field Effect [V/m]
parameter real    DE0 	     = -1; 	    	 	    // Vertical Field Effect power factor[V/m]
parameter real    UCRIT 	     = 4.0e6; 	    	 	    // Crutucal Field for velocity saturation
parameter real ACLM     = 220 	    from [0.0:inf];
parameter real DELTA     = 2.0	    from [0.0:inf]; //  order of VSAT model between 1-2
parameter real    CIT            = 0e-8  from [0.0:inf];      //"C/m^2"   Interface Trap density
parameter real    NFACTOR            = 0.0  from [0.0:inf];      //                       Sub-threshold slope factor
parameter real    CDSCD           =1e-9       from [0.0:inf];      //"F/m^2/V"        "d-bias sensitivity of sub-threshold slope" )
parameter real    CDSCB           =0       from [0.0:inf];      //"F/m^2/V"        "Body-bias sensitivity of sub-threshold slope" )
//parameter real    Cb 	     = 0.0026	    from (0.0:inf); // AlGaN CAPACITANCE PER UNIT AREA
parameter real    U0 	     = 0.165	    from (0.0:inf); // Low field mobility
parameter real    UA 	     = 3.0	    from [0.0:inf]; // Mobility reduction factor
parameter real    UC 	     = 0.0	    from [0.0:inf]; // Mobility reduction with body bias
parameter real    UD 	     = 37.0	    from [0.0:inf]; // Coulomb scattering parameter
parameter real    EU 	     = 1.0	    from [0.0:inf]; // Mobility reduction exponent
parameter real    BEX 	     = -2.0; 	    	 	    // Mobility temperature exponent
parameter real    UCEX 	     = 0.025; 	    	 	    // Longitudinal critical field temperature exponent
parameter real    ETAVSAT 	     = 0.5; 	    	 	    // Longitudinal critical field temperature coeff
parameter real    USC 	     = 1	    from [0.0:inf]; // Coulomb scattering parameter
parameter real    AVDSX 	     = 40	    from [5.0:100]; // Smoothing parameter in Vdsx in Vbsx
parameter real    LC 	     = 10e-9	    from (0:inf]; // LC
parameter real    LAMBDA     = 0.00	    from [0.0:inf]; // Depletion length coefficient (channel length modulation)
parameter real    PTWG     = 0.0	    from [0.0:inf]; // VG coefficient (channel length modulation)
parameter integer    TYPE=`type_n      from [-1:1];  // type_n=1  type_p=-1
parameter integer type            = 1             from[-1:1] exclude 0; //               nFET=1 pFET=-1
parameter real    rth             =30         from [0:inf);         // K/W           Thermal resistance
parameter real    cth             = 1e-9          from [0:inf);         // s.W/K         Thermal capacitance
parameter real    ns0    	     = 5.0e17*25	    from [0.0:inf];
parameter real    mu0acc    	     = 0.165	    from [0.0:inf];
parameter real    vsat0acc    	     =5.0e4	    from [0.0:inf];
parameter real    Rcs    	     = 1.0e-4	    from [0.0:inf];
parameter         ktrs               = 0.00          from [0.0:inf];
parameter         ktrd               =0.00          from [0.0:inf];
parameter real    Rcd    	     = 1.0e-4	    from [0.0:inf];
parameter real kth1    	     = 0.00  from [0.0:inf];
parameter real kth2    	     = 0.00	    from [0.0:inf];
parameter real kth3    	     = 0.0	    from [-inf:inf];
parameter real gsar    	     = 2.2	    from [-inf:inf];
parameter integer flagfp1         = 1             from[0:1];            //               Flag parameter: GFP=1 or SFP=0
parameter real    lgfp1           = 2e-6         from[0.0:inf];        // um            FP Length
parameter real    vtofp1          = -35.3         from[-inf:inf];       // V             FP Threshold Voltage
parameter real    cbfp1           = 0      from[0:inf];          // F/m           Body to d (under FP) Cap/Width
parameter real    minl            = 1.0e-9        from[0.0:inf];        // um            Minimum length
parameter real    minc            = 1.0e-15       from[0.0:inf];        // F             Minimum capacitance
parameter real    minr            = 1.0e-3        from[0.0:inf];        // Ohms          Minimum resistance
parameter real    rgsp            = 0.0           from[0.0:inf];        // Ohms*m        Gate resistance * Width
//
//***********************************************
//
// Clamped exponential function
//
//***********************************************
//
analog function real lexp;
    input x;
    real x;
    begin
        if (x > `EXPL_THRESHOLD) begin
            lexp = `MAX_EXPL * (1.0 + x - `EXPL_THRESHOLD);
        end else if (x < -`EXPL_THRESHOLD) begin
            lexp = `MIN_EXPL;
        end else begin
            lexp = exp(x);
        end
    end
endfunction
//
//***********************************************
//
// Clamped log function
//
//***********************************************
//
analog function real lln;
    input x;
    real x;
    begin
        lln = ln(max(x, `N_MINLOG));
    end
endfunction
//
//***********************************************
//
// Hyperbolic smoothing function
//
//***********************************************
//
analog function real hypsmooth;
    input x, c;
    real x, c;
    begin
        hypsmooth = 0.5 * (x + sqrt(x * x + 4.0 * c * c));
    end
endfunction
//
//***********************************************
//
 //sd_dir function
 //
//***********************************************
//
analog function real sd_dir;
    inout vgsout,vdsout;
    input type,vgsin,vgdin,vdsin;
    real  type,vgsout,vdsout,vgsin,vgdin,vdsin;
    real  vgsType,vgdType,vdsType;
    begin
       vgsType      = vgsin * type;
       vgdType      = vgdin * type;
       vdsType      = vdsin * type;
       vgsout       = vgsType;
       vdsout       = vdsType;
	  sd_dir       = 1.0;
    end
 endfunction // sd_dir
 //
//***********************************************
//
//core function
 analog function real core;
      input vch,pinch_n,n_q,gam,cb,DOS_2D,gg,UT,v_s,phib;
      real vrbl,vch,pinch_n,gam,cb,DOS_2D,gg,UT,phib;
      real v_s,a,n0,alpha,d,beta,n_q,Qsp;
 	 real T0,T1,T2,T3,T4;
 	 begin
      vrbl=pinch_n-v_s+phib-vch;
      Qsp=2*n_q*cb*UT;
      a=q/(cb*n_q);
      n0=DOS_2D*UT;
      alpha=a*n0/UT;
      if (vrbl <= 0.0) begin
 	     T0 = 6 / exp(vrbl);
          T1 =(T0+alpha+2/3*beta*(T0)**(1/3))/(1+vrbl+ln(T0)-1/3*beta*(T0)**(-2/3));
          T2 =(T1+alpha+2/3*beta*(T1)**(1/3))/(1+vrbl+ln(T1)-1/3*beta*(T1)**(-2/3));
          T4 =(1+vrbl+ln(T2)-1/3*beta*(T2)**(-2/3))/(T2+alpha+2/3*beta*(T2)**(1/3));
 		 core =q*n0*T4/Qsp;
      end else begin
 	 if (vrbl<50) begin
             T0=1/((vrbl/(alpha+beta))+0.5);
             T1=(T0+alpha+2/3*beta*(T0)**(1/3))/(1+vrbl+ln(T0)-1/3*beta*(T0)**(-2/3));
             T2=(T1+alpha+2/3*beta*(T1)**(1/3))/(1+vrbl+ln(T1)-1/3*beta*(T1)**(-2/3));
             T4=(1.0+vrbl+ln(T2)-1/3*beta*(T2)**(-2/3))/(T2+alpha+2/3*beta*(T2)**(1/3));
 			core =q*n0*T4/Qsp;
      end else begin
             T0=3/((vrbl/(alpha+beta))+0.5);
             T1=(1+alpha+2/3*beta*(T0)**(1/3))/(0.5+vrbl-1/3*beta*(T0)**(-2/3));
             T2=(1+alpha+2/3*beta*(T1)**(1/3))/(0.5+vrbl-1/3*beta*(T1)**(-2/3));
             T3=(1+alpha+2/3*beta*(T2)**(1/3))/(0.5+vrbl-1/3*beta*(T2)**(-2/3));
            T4=(1.0+1*vrbl-1/3*beta*(T3)**(-2/3))/(1.0+alpha+2/3*beta*(T3)**(1/3));
 		   core =q*n0*T4/Qsp;
      end
 	 end
 	 end
   endfunction //core
//
//***********************************************
//
//access function
//
//***********************************************
//
analog function real access;
     input R0,Vcrit,Vch,gsar;
     real R0,Vcrit,Vch,gsar,T0,T1,T2;

	 begin
     T0=Vch/Vcrit;
    T1=pow(T0,gsar);
	 T2=pow(1+T1,1/gsar);
     access=Vch/(R0*T2);
     end

 endfunction //access
 //
//***********************************************
//
analog function real calc_Ids;
//
//***********************************************
//
//**********output idsout*********************
input Vd,Vg,Vs,VA,cb,phist,UT,phib,Leff;
real idsout,Vgs,Vdss,Vd,Vg,Vs,VA,cb,pinch_n,phist,UT,phib,Leff;
//
//***********************************************
//
// Common variables
//
//***********************************************
//
integer type;
real T0, T1, T2, T3, T4, T5, T6, T7, T8, T9,T10,T11,T12;
real sigvds,vA,vg_vA, Vbsx;
real vg,vs,Vdsx,vd,VDAR,VSAR;
real Vth_shift;
real qia, qba, qbs, phib_n;
real nq, psiavg, pinch_norm_cl, sqrtpsip;
real Cdep;
real v_s,n0,dat,beta,n_q,Qsp,Vds;
//
//***********************************************
//
// Material Parameters
//
//***********************************************
//
real EgGaN,EgAlN,EgAlGaN;
real ep_AlGaN, Ef_AlGaN,DOS_2D;
//
//***********************************************
//
//CLM Parameters
//
//***********************************************
//
real diffVds,core,Core,a,vrbl,alpha;
real qsqdp,qs_qdp,powqs_qdp2,qsqdpp1;
//
//***********************************************
//
//drain saturation voltage
//
//***********************************************
//
real LambdaC,qdsat,vdsat,vdssat,qdeff;
real g_clm,e_clm,e_clmx2,e_clm2,e_clmp2,e_clmx2xqs;
real qs_qsat,qs_qsat2,mdm2,e_clmxmdm2_2,tmp_vdsat1,tmp_vdsat11,tmp_vdsat2;
real dv_clm,tmp_vdp1,tmp_vdp2,tmp_vdp3,vdp,u_clm,alpha_clm,deltal;
 //Short channel effects
real n, nUT, inv_nUT, inv_UT;
real PhistVbs, sqrtPhistVbs, Xdep, cdsc;
real T1DEP;
real dVth_dibl;
real gam, inv_gam, Phist;
//
//***********************************************
//
// Vertical Field
//
//***********************************************
//
real EeffF,Eeffs,eta_mu,qis,Vmr,Eeffm,E0_t;
//
//***********************************************
//
// charge variables
//
//***********************************************
//
real qs,vp;
real DQSD2,Qb,Qs,Qd;
real tambk, tsh, tdut, pdiss, mut, TRatio,UCRIT_T;
//
//***********************************************
//
// Velocity Saturation
//
//***********************************************
//
 real Dvsat,Dr;
 //
//***********************************************
//
 //transconductance
 //
//***********************************************
//
 real  difqdeff_VG,difqs_VG,difqdeff_VD,Gm,Gds;
 real Dtot,ueff,ids,Isp,IDS;
//
//***********************************************
//
begin
       DOS_2D=0.2*me/((1/q)*pi*(1.05459e-34)**2);

    Vds  = Vd - Vs;
    T0   = AVDSX * Vds;
    if (T0 > `EXPL_THRESHOLD) begin
       T1 = T0;
    end else begin
       T1 = ln(1.0 + exp(T0));
    end
    Vdsx = ((2.0/AVDSX) * T1) - Vds - ((2.0/AVDSX) * ln(2.0));
    Vbsx = -(Vs + 0.5 * (Vds - Vdsx));
$strobe(">- DOS_2D = %g V \t  Vds = %g V \t T1 = %g V \t Vdsx = %g V \t Vbsx = %g V \t", DOS_2D,  Vds,T1,Vdsx,Vbsx);
//
//***********************************************
//
   // SCE, DIBL, SS degradation effects
   //
//***********************************************
//
    `Smooth(Phist - Vbsx, 0.05, 0.1, PhistVbs)
    sqrtPhistVbs = sqrt(PhistVbs);
    Xdep         = T1DEP * sqrtPhistVbs;
    Cdep         = ep_GaN / Xdep;
    cdsc         = CIT + NFACTOR + CDSCD * Vdsx - CDSCB* Vbsx;
    T1           = 1.0 + cdsc/cb;
    `Smooth(T1, 1, 0.05, n)
    nUT     = n * UT;
    inv_nUT = 1.0 / nUT;
    vd    = Vd * inv_nUT;
    vg    = Vg * inv_nUT;
    vs    = Vs * inv_nUT;
    vA   = VA * inv_nUT;
//
//***********************************************
//
// Vth Shift for
//
//***********************************************
//
  dVth_dibl = -(ETA0 + ETAB * Vbsx) * Vdsx;
Vth_shift = dVth_dibl;

vg_vA      = vg - vA - Vth_shift * inv_nUT;
gam     = sqrt(2.0 * q * ep_GaN* NDEP * inv_UT) / cb;
inv_gam=1/gam;
phib_n = phib / n;
//
//***********************************************
//
`pinch_norm(vg_vA, gam, pinch_n)
`Smooth(pinch_n, 1.0, 2.0, pinch_norm_cl)
   sqrtpsip = sqrt(pinch_norm_cl);
   n_q=1+gam/(2*sqrt(pinch_norm_cl));
     Qsp=2*n_q*cb*UT;
dat=gg/UT;
beta=dat*n0**(0.6666);
v_s=ln(NDEP/NV)+EgGaN/(q*UT);
//end function
qs=core(vs,pinch_n,n_q,gam,cb,DOS_2D,gg,UT,v_s,phib);
// source side surf pot.
psiavg = pinch_n - 2.0 * qs;
`Smooth(psiavg, 1.0, 2.0, T0);
nq = 1.0 + gam / (sqrtpsip + sqrt(T0));

//
//***********************************************
//
 EeffF =cb /(E0_t*ep_GaN);
 T0 = nUT * (vg_vA - pinch_n - 2.0 * qs * (nq - 1.0));
 `Smooth(T0, 0, 0.1, qbs)
//
//***********************************************
//
// Source side qi and qb for Vdsat
//
//***********************************************
//
 qis = 2.0 * nq * nUT * qs;
 Eeffs = EeffF * (qbs + eta_mu * qis);
//
//***********************************************
//
//  mobility model
//
//***********************************************
//
 T2 = pow(0.5 * (1.0 + (qis / qbs)), USC);
 T3 = (UA + UC * Vbsx) * pow(Eeffs, EU) + UD / T2;
 T4 = 1.0 + T3;
 `Smooth(T4, 1.0, 0.0015, Vmr)
UCRIT_T  = UCRIT * pow(TRatio, -UCEX);
//
//***********************************************
//
// Saturation Voltage
//
//***********************************************
//
    vp 		= pinch_n  - phib;
	//
//***********************************************
//
// -- VELOCITY SATURATION (NOT DEPENDENT ON VD)
//
//***********************************************
//
	g_clm 		= 0.1; // NOTE: Also used for the calculation of mobility reduction due to CHANNEL LENGTH MODULATION
	e_clm 		= 2.0*nUT / (UCRIT_T*L); // NOTE: Also used for the calculation of mobility reduction due to CHANNEL LENGTH MODULATION
	e_clm2 		= e_clm * e_clm; // NOTE: Also used for the calculation of mobility reduction due to CHANNEL LENGTH MODULATION
	e_clmx2 	= 2.0 * e_clm;
	e_clmp2 	= 2.0 + e_clm;
	e_clmx2xqs 	= e_clmx2 * qs;
	qdsat 		= e_clmx2 * (qs**2 + qs) / (e_clmp2 + e_clmx2xqs + sqrt(e_clmp2 * e_clmp2 + 4.0 * e_clmx2xqs)); // NOTE: The inversion charge at a point of maximum velocity saturation.
	qs_qsat 	= qs - qdsat;
	qs_qsat2 	= qs_qsat * qs_qsat;
	mdm2 		= 2.0 - DELTA; // NOTE: Also used for the calculation of mobility reduction due to CHANNEL LENGTH MODULATION
	e_clmxmdm2_2 	= e_clm2 * mdm2 * mdm2; // NOTE: Also used for the calculation of mobility reduction due to CHANNEL LENGTH MODULATION
	tmp_vdsat1 	= (2.0 * qdsat + ln(qdsat)) * (1.0 + e_clm * qs_qsat);
 	tmp_vdsat11	= g_clm + e_clm * mdm2 * qs_qsat;
 	tmp_vdsat2 	= sqrt(1.0 + (2.0 * e_clm2 * mdm2 * mdm2 * qs_qsat2) / tmp_vdsat11 + e_clm2 * qs_qsat2);
 	vdsat 		= vp - tmp_vdsat1 / tmp_vdsat2; // NOTE: The potential at a point of the channel of maximum velocity saturation.
	`Smooth(vdsat - vs, 3.0, 4, vdssat)
	//
//***********************************************
//
// -- VELOCITY SATURATION (DEPENDENT ON VD)
//
//***********************************************
//
 	dv_clm 		= (ACLM / DELTA) * (4.0 * qdsat + DELTA) / (qs + 1.0);
	tmp_vdp1 	= (vd - vs) * sqrt(1.0 + 4.0 * dv_clm / vdssat);
	tmp_vdp2 	= sqrt((tmp_vdp1 + vdssat) * (tmp_vdp1 + vdssat) + 4.0 * dv_clm * vdssat);
	tmp_vdp3 	= sqrt((tmp_vdp1 - vdssat) * (tmp_vdp1 - vdssat) + 4.0 * dv_clm * vdssat);
	vdp 		= 0.5 * (tmp_vdp2 - tmp_vdp3) + vs; // NOTE: The potential at the velocity saturated point of the channel, limited by the maximum value (vdsat)
	//
//***********************************************
//
// -- CHANNEL LENGTH MODULATION
//
//***********************************************
//
	u_clm		= 0.5 * e_clm * Leff / LC * (vd - vdp);
	alpha_clm 	= LC / (Leff - 2.0 * LC);
	deltal 		= LAMBDA * LC * ln((alpha_clm + u_clm + sqrt(u_clm * u_clm + 2.0 * alpha_clm * u_clm + 1.0)) / (alpha_clm + 1.0)); // NOTE: The distance between the velocity saturated point of the channel and the (electrical) drain end. Used at the SPECIFIC CURRENT calculation.
//
//***********************************************
//
// CALCULATION OF NORMALIZED INVERSION CHARGE OF THE VELOCITY SATURATED POINT (ELECTRICAL DRAIN END)
//
//***********************************************
//
qdeff=core(vdp,pinch_n,nq,gam,cb,DOS_2D,gg,UT,v_s,phib);// Reevaluation of nq to include qdeff
psiavg = pinch_n -qs-qdeff;
`Smooth(psiavg, 1.0, 2.0, T0)
T2 = sqrt(T0);
nq = 1.0 + gam / (sqrtpsip + T2);
//
//***********************************************
//
    // Inversion and bulk charge
	//
//***********************************************
//
    DQSD2 = (qs - qdeff) * (qs - qdeff);
    T0    = 1.0 / (1.0 + qs + qdeff);
    T1    = DQSD2 * T0;
    Qb    = vg_vA - pinch_n - (nq - 1.0) * (qs + qdeff + `Oneby3 * T1);
    T2    = `Oneby3 * nq;
    T3    = T1 * T0;
    Qs    = T2 * (2.0 * qs + qdeff + 0.5 * (1.0 + 0.8 * qs + 1.2 * qdeff) * T3);
    Qd    = T2 * (qs + 2.0 * qdeff + 0.5 * (1.0 + 1.2 * qs + 0.8 * qdeff) * T3);
 //
//***********************************************
//
    // Mobility degradation
    // Average charges (qba and qia) - normalized to Cb
	//
//***********************************************
//
    `Smooth(nUT * Qb, 0, 0.1, qba)
    qia   = nUT * (Qs + Qd);
    Eeffm = EeffF * (qba + eta_mu * qia);
    T2    = pow(0.5 * (1.0 + (qia / qba)), USC);
    T3    = (UA + UC * Vbsx) * pow(Eeffm, EU) + UD / T2;
    T4    = 1.0 + T3;
    `Smooth(T4, 1.0, 0.0015, Vmr)
//
//***********************************************
//
	qsqdp 		= qs + qdeff;
	qs_qdp 		= qs - qdeff;
	powqs_qdp2 	= qs_qdp * qs_qdp;
	qsqdpp1 	= qsqdp + 1.0;
	Dvsat 	= sqrt(1.0 + 4.0 * e_clmxmdm2_2 * powqs_qdp2 / (g_clm + e_clm * mdm2 * (qs_qdp)) + e_clm2 * powqs_qdp2);
//
//***********************************************
//
   Dr=1;
   Dtot = Vmr * Dvsat * Dr;

    // Effective mobility including mobility degradation
 ueff = mut / Dtot;

  Isp=2.0 * NF * nq * ueff * W / (Leff-deltal) * cb * nUT * nUT ;
//
//***********************************************
//
 idsout  = Isp * ((qs - qdeff) * (1.0 + qs + qdeff));
  T1=q/(nq*Qsp);
T2=1/DOS_2D;
T3=-(Qsp*qs/q)/(DOS_2D*UT);
T4=T2/(1-exp(T3));
T5=q/(cb*nq);
T6=2*gg/(3*((Qsp*qs/q)**(1/3)));
difqs_VG=T1/(T4+T5+T6);
T1=q/(nq*Qsp);
T2=1/DOS_2D;
T3=-(Qsp*qdeff/q)/(DOS_2D*UT);
T4=T2/(1-exp(T3));
T5=q/(cb*nq);
T6=2*gg/(3*((Qsp*qdeff/q)**(1/3)));
difqdeff_VG=T1/(T4+T5+T6);
T1=q/(nq*Qsp);
T2=1/DOS_2D;
T3=-(Qsp*qdeff/q)/(DOS_2D*UT);
T4=T2/(1-exp(T3));
T5=q/(cb*nq);
T6=2*gg/(3*((Qsp*qdeff/q)**(1/3)));
difqdeff_VD=T1/(T4+T5+T6);
Gm=Isp * (difqs_VG*(1+2*qs)-difqdeff_VG*(1+2*qdeff));
Gds=-Isp *difqdeff_VD*(1+2*qdeff);
lc_Ids=idsout;
   end
  endfunction
  //
//***********************************************
//
// S/D Series Resistance
//series resistance
//
//***********************************************
//
real nsacc, vsatacc, muacc, qacc;
real Rd0,Rs0,Rd,Rs,Rcos,Rcod;
real Iaccs,Iaccd;
real Vcrits,Vcritd;
 real  leff, leffs, leffd, lefffp1;
real VDAR,VSAR;
real phibb;
real Cb;
//
//***********************************************
//
// Material Parameters
real EgGaN,EgAlN,EgAlGaN;
real ep_AlGaN, Ef_AlGaN,DOS_2D,ni_gan;
real  UT, inv_UT;
 real phistt;
 real T1DEP;
// Vertical Field
real eta_mu,E0_t;
//
//***********************************************
//
// charge variables
real tambk, tsh, tdut, pdiss, mut, TRatio;
//
//***********************************************
//
 real Dvsat,Dr;

 //real  difqdeff_VG,difqs_VG,difqdeff_VD,Gm,Gds;
 real ueff,ids,IDS;

  real dir, dirfp1;
  real vdsi, vgsi,vsi,vdi,vgi,vdsrd,vgsfp1,vdsfp1,vcfp1,vbfp1;
  real idsfp1;
//real itfp,iti;
real vsfp1,vdfp1,vgfp1,vfp1,vdi1,vsi1;
real gmi,gdsi,gmfp1,gdsfp1,T0,T1,T2,Rd1,Rs1;
   real rd, rs, rg;
//
//******************ac*****************************
//
analog begin
	  leff=L;
      leffs           = lgs ;
      leffd           = lgd ;
      lefffp1         = lgfp1;
      DOS_2D=0.2*me/((1/q)*pi*(1.05459e-34)**2);
      tambk              = $temperature;
      tsh                = Temp(t);
      tdut               = tambk + tsh;

      TRatio     = tdut / TNOM;
      UT = 0.0259*(tdut/TNOM);
$strobe(">- tambk = %g V \t tsh = %g V \t tdut = %g V \t UT = %g V \t", tambk, tsh, tdut, UT);
//
//***********************************************
//
       EgGaN = 3.507*q-(0.909e-3)*tdut**2/(tdut+830)*q; //Joule
       EgAlN = 6.23*q-(1.799e-3)*tdut**2/(tdut+1462)*q; //Joule
       EgAlGaN= EgAlN*xx+EgGaN*(1-xx)*1.3*xx*(1-xx)*q; //Joule
       ep_AlGaN=(8.5*xx+8.9*(1-xx))*`EP0;
       Ef_AlGaN =0*q;
	   // Mobility degradation
       eta_mu = (TYPE != `type_n) ? (0.3333) : (0.5);
	   mut   = U0 * pow(TRatio, BEX);
	   E0_t=E0*pow(TRatio, DE0);
	  inv_UT=1/UT;
   	ni_gan=sqrt(NC_GaN*NV)*exp(-EgGaN/(2*q*UT));
     phibb=lln(NDEP/(ni_gan));
     phistt     = max(0.4 + UT * phibb + PHIN, 0.4);
	 T1DEP     = sqrt(2.0 * ep_GaN / (q * NDEP));
	 Cb=ep_AlGaN/x1;
	 $strobe(">- phistt = %g V \t Cb = %g V \t phibb = %g V \t ", phistt, Cb,phibb);
	 //
//***********************************************
//
  // Determines source for intrinsic transistor
     rg                 = ( rgsp / W / NF);
  nsacc=ns0;
	 vsatacc=vsat0acc*(1-kth1*(TRatio-1))**kth2;
	 muacc=mu0acc*pow(TRatio, kth3);
	 qacc=q*nsacc*W;
  	 VDAR=V(d,fp1);
	  Rd0=leffd/(W*qacc*muacc)*(1-kth1*(TRatio-1));
	  Vcritd=vsatacc/muacc*leffd;
	  Rcod=Rcd/W;
	  Rd=Rcod*(1+ktrd*pow(TRatio,1));
	    T0=0;
	 T1=0;
	 T2=0;
	     T0=VDAR/Vcritd;
     T1=pow(T0,gsar);
	 T2=pow(1+T1,1/gsar);
    Rd1=Rd0*T2;
	Iaccd=VDAR/Rd1;
  I(d,fp1)          <+V(d,fp1)/Rd1;
  $strobe(">- idfp1 = %g V \t T0 = %g V \t T1 = %g V \t T2 = %g V \t ",  I(d,fp1) , T0 , T1 , T2);
  dirfp1          = sd_dir(vgsfp1,vdsfp1,type,V(g,di),V(g,fp1),V(fp1,di));
  idsfp1          = calc_Ids(V(fp1,b),V(g,b),V(di,b),vtofp1,Cb,phistt,UT,phibb,lgfp1);
  I(fp1,di)       <+ calc_Ids(V(fp1,b),V(gi,b),V(di,b),vtofp1,Cb,phistt,UT,phibb,lgfp1) ;
    dir = sd_dir(vgsi,vdsi,type,V(g,si),V(g,di),V(di,si));
	 	 $strobe(">- idsfp1 = %g V \t  ", I(fp1,di) );

	   // ids                = calc_Ids(V(di,b),V(g,b),V(si,b),vto,Cb,phistt,UT,phibb,leff);//0,0,0,dir,tdut,tnomk,phit,weff,leff,cg,0,0,0,vto,ss,delta1,delta2,nd,alpha,vx0,mu0,beta,mtheta,vtheta,vtzeta,dibsat,epsilon,vzeta,lambda,ngf,type);
	 //$strobe(">- ids = %g V \t  ", ids);
   I(di,si)           <+ calc_Ids(V(di,b),V(gi,b),V(si,b),vto,Cb,phistt,UT,phibb,leff) ;
   VSAR=V(si,s);
	 $strobe(">- VDAR = %g V \t VSAR = %g V \t  ", VDAR, VSAR);
  //
//***********************************************
//
	 Rs0=leffs/(W*qacc*muacc)*(1-kth1*(TRatio-1));
	 Vcrits=vsatacc/muacc*leffs;
	  T0=0;
	 T1=0;
	 T2=0;
     T0=VSAR/Vcrits;
     T1=pow(T0,gsar);
	 T2=pow(1+T1,1/gsar);
    Rs1=Rs0*T2;
      I(si,s)          <+V(si,s)/Rs1;
	 //fp1,vbfp1,flagfp1s,dirfp1,tdut,tnomk,phit,weff,lefffp1,cgfp1,cfp1s,ccfp1,cbfp1,vtofp1,sfp1,delta1fp1,0.0,ndfp1,alphafp1,vx0fp1,mu0fp1,betafp1,mthetafp1,vthetafp1,vtzeta,dibsat,epsilon,vzeta,lambda,ngf,type);
   $strobe(">- isis = %g V \t T0 = %g V \t T1 = %g V \t T2 = %g V \t ",  I(si,s) , T0 , T1 , T2);

vgsfp1=V(g,di);
vdsfp1=V(fp1,di);
vgsi=V(g,si);
vdsi=V(di,si);
vfp1=V(fp1,b);
vdi1=V(di,b);
vsi1=V(si,b);
$strobe(">- vgsfp1 = %g V \t vdsfp1 = %g V \t vfp1 = %g V \t ", V(g,di),V(fp1,di),V(fp1,b));
	 $strobe(">- vgsi = %g V \t vdsi = %g V \t vdi = %g V \t vsi = %g V \t ", V(g,si), V(di,si),V(di,b),V(si,b));

   if (rg < minr) begin
      V(g,gi)         <+ 0;
   end else begin
     I(g,gi)          <+  V(g,gi) / rg;
   end
   idsfp1          = calc_Ids(idsfp1,qgsfp1,qgdfp1,qcfp1,vdfp1,vsfp1,vgfp1,0,vtofp1,cbfp1,pinch_n,phistt,UT,phibb); fp1,vbfp1,flagfp1s,dirfp1,tdut,tnomk,phit,weff,lefffp1,cgfp1,cfp1s,ccfp1,cbfp1,vtofp1,sfp1,delta1fp1,0.0,ndfp1,alphafp1,vx0fp1,mu0fp1,betafp1,mthetafp1,vthetafp1,vtzeta,dibsat,epsilon,vzeta,lambda,ngf,type);

 ids                = 0;
 ids                = calc_Ids(ids,qgs,qgd,qc,vdi,vsi,vgi,0,vto,cbfp1,pinch_n,phistt,UT,phibb);//0,0,0,dir,tdut,tnomk,phit,weff,leff,cg,0,0,0,vto,ss,delta1,delta2,nd,alpha,vx0,mu0,beta,mtheta,vtheta,vtzeta,dibsat,epsilon,vzeta,lambda,ngf,type);

     I(di,si)           <+ ids ;

     VDAR=V(d,fp1);

	 Iaccd=access(Rd0,Vcritd,VDAR,gsar);
	 Iaccs=access(Rs0,Vcrits,VSAR,gsar);
Rcos=Rcs/W;
 Rs=Rcos*(1+ktrs*pow(TRatio,1));
 V(gi)<+   V(g);
 V(gfp)<+   V(g);
 I(si,s)          <+ Iaccs;
I(d,fp1)          <+ Iaccd;
Dr=1;
Dr      = 1.0 + U0 /(Dvsat * Vmr) * Cb * W / (leff-deltal) * qia * (Rs+Rd);
$strobe(">- VDAR = %g V \t VSAR = %g V \t Vcritd = %g V \t ", VDAR, VSAR,Vcritd);

//
//***********************************************
//
   // Self-heating
   //
//***********************************************
//
   if (rth !=0) begin

      pdiss            = -( I(di,si) * V(di,si)+ I(d,fp1) * V(d,fp1) + I(si,s) * V(si,s) + I(fp1,di) * V(fp1,di));
      Pwr(t)          <+ ddt( (cth ) * Temp(t));
      Pwr(t)          <+ pdiss;
      Pwr(t)          <+ Temp(t) / rth;
   end
   else
      Pwr(t)          <+ Temp(t) * 1e9;

end

endmodule
