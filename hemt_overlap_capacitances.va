// *****************************************************************************
//  HEMT Extrinsic Resistances and Bias-Independent Overlap Capacitances
//  Part of GaN HEMT Compact Model Library
//
//  Version      : v1.0.0
//  Release Date : 2026-06-19
//
//  Description:
//      This section models extrinsic source/drain/gate resistances and
//      bias-independent overlap capacitances for GaN HEMT devices.
//      Includes geometry scaling, temperature dependence, and first-order
//      resistance correction effects.
//
//
//  Developed by:
//
//  * Sahra Ebrahimmagham (Researcher, AUT)
//  * Dr. Majid Shalchian (Assistant Professor, AUT)
//  * Dr. Farzan Jazaeri (Researcher, EPFL)
//
//  Affiliations:
//
//  * Amirkabir University of Technology (AUT)
//  * École Polytechnique Fédérale de Lausanne (EPFL)
//
//
//  ## License
//
//This project is released under the **MIT License**.
//
//See `LICENSE` file for details.
// *****************************************************************************
//
// *****************************************************************************
// EXTRINSIC SOURCE / DRAIN RESISTANCE MODEL (HEMT)
// *****************************************************************************
//
//
begin : HEMT_EXTRINSIC_RESISTANCES

    // *****************************************************************************
	//
    // Geometry-based or user-defined resistance selection
	//
    // *****************************************************************************

    if (RLX < 0.0) begin

        // Source resistance
        if (RSX < 0.0)
            hemt_rs = (hdif * RSH + (ldif - DL / 2.0) * RS) / WeffNF;
        else
            hemt_rs = RSX / WeffNF;

        // Drain resistance
        if (RDX < 0.0)
            hemt_rd = (hdif * RSH + (ldif - DL / 2.0) * RD) / WeffNF;
        else
            hemt_rd = RDX / WeffNF;

    end else begin
        // Symmetric/asymmetric unified model override
        hemt_rs = RLX / WeffNF;
        hemt_rd = hemt_rs;
    end

    // *****************************************************************************
	//
    // Width scaling of extrinsic resistances
	//
    // *****************************************************************************

    tmp = (1.0 + WRLX / Weff);

    hemt_rs_w = hemt_rs * tmp;
    hemt_rd_w = hemt_rd * tmp;

    // *****************************************************************************
    //
    // Temperature dependence of resistances
	//
    // *****************************************************************************

    hemt_Mr_t = (1.0 + TR * dT + TR2 * dT2);

    hemt_rs_t = hemt_rs_w * hemt_Mr_t;
    hemt_rd_t = hemt_rd_w * hemt_Mr_t;

    rb_t  = rb  * hemt_Mr_t;
    rsb_t = rsb * hemt_Mr_t;
    rdb_t = rdb * hemt_Mr_t;

    // *****************************************************************************
	//
    // Resistance clipping for numerical stability
	//
    // *****************************************************************************

    hemt_rs_t = `MAX(hemt_rs_t, `MINIMUM_RESISTANCE);
    hemt_rd_t = `MAX(hemt_rd_t, `MINIMUM_RESISTANCE);
    rb_t      = `MAX(rb_t,      `MINIMUM_RESISTANCE);
    rsb_t     = `MAX(rsb_t,     `MINIMUM_RESISTANCE);
    rdb_t     = `MAX(rdb_t,     `MINIMUM_RESISTANCE);

    end // HEMT_EXTRINSIC_RESISTANCES

     // *****************************************************************************
     //
     // BIAS-INDEPENDENT OVERLAP CAPACITANCES (HEMT)
	 //
     // *****************************************************************************

    tmp = M * WeffNF;

    // Gate overlap capacitances
    I(g, s) <+ ddt(hemt_CGSO * tmp * V(g, s));
    I(g, d) <+ ddt(hemt_CGDO * tmp * V(g, d));
    I(g, b) <+ ddt(hemt_CGBO * M * 2.0 * Leff * NF * V(g, b));

    // *****************************************************************************
    //
    // FIRST-ORDER CHANNEL CURRENT CORRECTION (RESISTIVE EFFECT)
    //
    // *****************************************************************************

    HEMT_RES_IDS = 1.0  + hemt_rs_t * Gspec_dits * qs  + hemt_rd_t * Gspec_dits * qdp;
